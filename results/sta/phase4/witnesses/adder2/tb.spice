TritFlow ternary testbench
*
.parameters vthMP	= 0
.parameters vthMN 	= 0
.parameters vthMPE      = 0
.parameters vthMNE      = 0
.parameters magRR       = 1
.parameters magRS       = 1
.parameters magCSIO     = 1
.include "/home/ishi-kai/pdk/TR-1um-pinned/libs.tech/spice/models/models_IP62_cap_v5p1.lib"
.include "/home/ishi-kai/pdk/TR-1um-pinned/libs.tech/spice/models/models_IP62_diode_v2.lib"
.include "/home/ishi-kai/pdk/TR-1um-pinned/libs.tech/spice/models/models_IP62_mos_v2.lib"
.include "/home/ishi-kai/pdk/TR-1um-pinned/libs.tech/spice/models/models_IP62_res_v5.lib"
* net tf_615b305d = a[0]
* net tf_615b315d = a[1]
* net tf_625b305d = b[0]
* net tf_625b315d = b[1]
* net tf_73756d5b305d = sum[0]
* net tf_73756d5b315d = sum[1]
* Created by KLayout
*** My special header ***

* cell adder2
* pin VDD
* pin VMID
* pin VSS
* pin cin
* pin cout
* pin tf_615b305d
* pin tf_615b315d
* pin tf_625b305d
* pin tf_625b315d
* pin tf_73756d5b305d
* pin tf_73756d5b315d
.SUBCKT adder2 VDD VMID VSS cin cout tf_615b305d tf_615b315d tf_625b305d tf_625b315d tf_73756d5b305d tf_73756d5b315d
* cell instance $1 m90 *1 618,42
X_ex_1 VDD n_ex_I135 cout VSS INV
* cell instance $2 m90 *1 618,942
X_ex_2 VDD n_ex_I134 n_ex_I144 VSS INV
* cell instance $3 m90 *1 210,762
X_ex_3 VDD tf_615b305d n_ex_I143 VSS INV
* cell instance $4 m90 *1 1110,222
X_ex_4 VDD n_ex_I132 n_ex_I142 VSS INV
* cell instance $5 m90 *1 1026,762
X_ex_5 VDD n_ex_I131 n_ex_I141 VSS INV
* cell instance $6 m90 *1 1110,942
X_ex_6 VDD n_ex_I130 n_ex_I140 VSS INV
* cell instance $7 m90 *1 786,402
X_ex_7 VDD n_ex_I129 n_ex_I139 VSS INV
* cell instance $8 r0 *1 918,402
X_ex_8 VDD n_ex_I128 n_ex_I138 VSS INV
* cell instance $9 r0 *1 918,42
X_ex_9 VDD n_ex_I127 n_ex_I137 VSS INV
* cell instance $10 m90 *1 408,582
X_ex_10 VMID n_ex_I90 n_ex_I141 VDD tf_73756d5b305d VSS NANY
* cell instance $11 m90 *1 378,762
X_ex_11 VMID n_ex_I91 tf_625b315d VDD n_ex_I106 VSS NANY
* cell instance $12 m90 *1 240,222
X_ex_12 VMID tf_625b305d tf_615b305d VDD n_ex_I105 VSS NANY
* cell instance $13 m90 *1 408,942
X_ex_13 VMID n_ex_I101 n_ex_I140 VDD n_ex_I104 VSS NANY
* cell instance $14 m90 *1 648,222
X_ex_14 VMID n_ex_I95 n_ex_I139 VDD tf_73756d5b315d VSS NANY
* cell instance $15 m90 *1 816,222
X_ex_15 VMID n_ex_I95 n_ex_I92 VDD n_ex_I135 VSS NANY
* cell instance $16 m90 *1 786,942
X_ex_16 VMID n_ex_I140 n_ex_I134 VDD n_ex_I101 VSS NANY
* cell instance $17 m90 *1 678,402
X_ex_17 VMID cin n_ex_I132 VDD n_ex_I100 VSS NANY
* cell instance $18 r0 *1 480,582
X_ex_18 VMID n_ex_I95 n_ex_I101 VDD n_ex_I129 VSS NANY
* cell instance $19 r0 *1 618,42
X_ex_19 VMID n_ex_I87 n_ex_I105 VDD n_ex_I127 VSS NANY
* cell instance $20 r0 *1 648,582
X_ex_20 VMID n_ex_I100 cin VDD n_ex_I97 VSS NANY
* cell instance $21 r0 *1 564,762
X_ex_21 VMID n_ex_I90 n_ex_I100 VDD n_ex_I131 VSS NANY
* cell instance $22 r0 *1 72,942
X_ex_22 VMID n_ex_I104 n_ex_I144 VDD n_ex_I95 VSS NANY
* cell instance $23 r0 *1 1026,42
X_ex_23 VMID n_ex_I87 n_ex_I137 VDD n_ex_I132 VSS NANY
* cell instance $24 r0 *1 1026,402
X_ex_24 VMID n_ex_I92 n_ex_I138 VDD n_ex_I134 VSS NANY
* cell instance $25 r0 *1 72,582
X_ex_25 VMID n_ex_I106 n_ex_I146 VDD n_ex_I92 VSS NANY
* cell instance $26 r0 *1 210,402
X_ex_26 VMID tf_625b315d tf_615b315d VDD n_ex_I91 VSS NANY
* cell instance $27 m90 *1 210,402
X_ex_27 VDD tf_615b315d n_ex_I146 VSS INV
* cell instance $28 r0 *1 972,582
X_ex_28 VMID n_ex_I97 n_ex_I142 VDD n_ex_I90 VSS NANY
* cell instance $29 r0 *1 240,222
X_ex_29 VMID n_ex_I92 n_ex_I91 VDD n_ex_I128 VSS NANY
* cell instance $30 r0 *1 1026,762
X_ex_30 VMID n_ex_I90 n_ex_I87 VDD n_ex_I130 VSS NANY
* cell instance $31 r0 *1 240,42
X_ex_31 VMID n_ex_I108 n_ex_I143 VDD n_ex_I87 VSS NANY
* cell instance $32 m90 *1 240,42
X_ex_32 VMID n_ex_I105 tf_625b305d VDD n_ex_I108 VSS NANY
* Estimated lumped wire C to substrate (node 0); not signoff PEX
Ctfwire0 VDD 0 4.7353946124e-12
Ctfwire1 VMID 0 3.2057359232e-12
Ctfwire2 tf_615b315d 0 1.063657872e-13
Ctfwire3 tf_615b305d 0 1.220348436e-13
Ctfwire4 tf_625b315d 0 1.49052097e-13
Ctfwire5 tf_625b305d 0 1.122614598e-13
Ctfwire6 tf_73756d5b315d 0 1.424803366e-13
Ctfwire7 tf_73756d5b305d 0 1.84957235e-13
Ctfwire8 cin 0 1.668015446e-13
Ctfwire9 cout 0 1.146033606e-13
Ctfwire10 VSS 0 3.734973314e-12
Ctfwire11 n_ex_I146 0 7.9703307e-14
Ctfwire12 n_ex_I144 0 8.98137446e-14
Ctfwire13 n_ex_I143 0 2.26666961e-13
Ctfwire14 n_ex_I142 0 8.3970627e-14
Ctfwire15 n_ex_I141 0 1.00225805e-13
Ctfwire16 n_ex_I140 0 1.419067468e-13
Ctfwire17 n_ex_I139 0 4.75543066e-14
Ctfwire18 n_ex_I138 0 4.45814966e-14
Ctfwire19 n_ex_I137 0 4.45814966e-14
Ctfwire20 n_ex_I135 0 9.79060928e-14
Ctfwire21 n_ex_I134 0 1.912125402e-13
Ctfwire22 n_ex_I132 0 1.597199142e-13
Ctfwire23 n_ex_I131 0 8.40478584e-14
Ctfwire24 n_ex_I130 0 5.89231184e-14
Ctfwire25 n_ex_I129 0 7.04988944e-14
Ctfwire26 n_ex_I128 0 1.030536464e-13
Ctfwire27 n_ex_I127 0 6.46230544e-14
Ctfwire28 n_ex_I108 0 8.26648894e-14
Ctfwire29 n_ex_I106 0 2.438968974e-13
Ctfwire30 n_ex_I105 0 1.843952172e-13
Ctfwire31 n_ex_I104 0 8.15631694e-14
Ctfwire32 n_ex_I101 0 1.352958168e-13
Ctfwire33 n_ex_I100 0 1.818608812e-13
Ctfwire34 n_ex_I97 0 8.09502454e-14
Ctfwire35 n_ex_I95 0 2.407859698e-13
Ctfwire36 n_ex_I92 0 2.51927663e-13
Ctfwire37 n_ex_I91 0 1.995490112e-13
Ctfwire38 n_ex_I90 0 2.095426494e-13
Ctfwire39 n_ex_I87 0 2.68317153e-13
.ends adder2

* cell INV
* pin VDD
* pin A
* pin Y
* pin VSS
.SUBCKT INV VDD A Y VSS
* device instance $1 r0 *1 19.2,56 PMOS
XM_ex_1 n_ex_5 A VDD VDD PMOS L=1u W=13.5u AS=37.8p AD=37.8p PS=32.6u PD=32.6u
* device instance $2 r0 *1 19.2,26 NMOS
XM_ex_2 n_ex_6 A VSS VSS NMOS L=1u W=5u AS=14p AD=14p PS=15.6u PD=15.6u
* device instance $3 r0 *1 70,44 F_RR
XR_ex_3 n_ex_6 Y VDD F_RR R=10.7142857143 L=30u W=2.8u A=84p P=65.6u m=1
* device instance $4 r0 *1 70,57 F_RR
XR_ex_4 n_ex_5 Y VDD F_RR R=10.7142857143 L=30u W=2.8u A=84p P=65.6u m=1
.ENDS INV

* cell NANY
* pin VMID
* pin B
* pin A
* pin VDD
* pin Y
* pin VSS
.SUBCKT NANY VMID B A VDD Y VSS
* device instance $1 r0 *1 41,100 PMOS
XM_ex_1 n_ex_30 B n_ex_44 VDD PMOS L=1u W=34u AS=95.2p AD=95.2p PS=73.6u PD=73.6u
* device instance $2 r0 *1 26,100 PMOS
XM_ex_2 n_ex_44 A VDD VDD PMOS L=1u W=34u AS=95.2p AD=95.2p PS=73.6u PD=73.6u
* device instance $3 r0 *1 56,100 PMOS
XM_ex_3 n_ex_8 A Y VDD PMOS L=1u W=14u AS=39.2p AD=39.2p PS=33.6u PD=33.6u
* device instance $4 r0 *1 71,100 PMOS
XM_ex_4 n_ex_10 B Y VDD PMOS L=1u W=14u AS=39.2p AD=39.2p PS=33.6u PD=33.6u
* device instance $5 r0 *1 26,27 NMOS
XM_ex_5 n_ex_17 A n_ex_6 VSS NMOS L=1u W=11u AS=30.8p AD=30.8p PS=27.6u PD=27.6u
* device instance $6 r0 *1 41,27 NMOS
XM_ex_6 VSS B n_ex_17 VSS NMOS L=1u W=11u AS=30.8p AD=30.8p PS=27.6u PD=27.6u
* device instance $7 r0 *1 56,27 NMOS
XM_ex_7 n_ex_8 B VMID VSS NMOS L=1u W=8u AS=22.4p AD=22.4p PS=21.6u PD=21.6u
* device instance $8 r0 *1 71,27 NMOS
XM_ex_8 n_ex_10 A VMID VSS NMOS L=1u W=8u AS=22.4p AD=22.4p PS=21.6u PD=21.6u
* device instance $9 r0 *1 118.5,54 F_RR
XR_ex_9 n_ex_6 Y VDD F_RR R=10.7142857143 L=30u W=2.8u A=84p P=65.6u m=1
* device instance $10 r0 *1 118.5,84 F_RR
XR_ex_10 n_ex_30 Y VDD F_RR R=10.7142857143 L=30u W=2.8u A=84p P=65.6u m=1
.ENDS NANY

.temp 27
.options rshunt=1e12
VDD VDD 0 5
VMID VMID 0 0
VSS VSS 0 -5
Xdut VDD VMID VSS cin cout tf_615b305d tf_615b315d tf_625b305d tf_625b315d tf_73756d5b305d tf_73756d5b315d adder2
Vin0 tf_615b315d 0 PWL(0 0 1e-06 0 1.001e-06 5 2e-06 5 2.001e-06 5 3e-06 5 3.001e-06 5 4e-06 5 4.001e-06 -5 5e-06 -5 5.001e-06 -5 6e-06 -5 6.001e-06 -5 7e-06 -5 7.001e-06 5 8e-06 5 8.001e-06 5 9e-06 5 9.001e-06 0 1e-05 0 1.0001e-05 0 1.1e-05 0 1.1001e-05 -5 1.2e-05 -5 1.2001e-05 5 1.3e-05 5 1.3001e-05 5 1.4e-05 5 1.4001e-05 0 1.5e-05 0 1.5001e-05 -5 1.6e-05 -5 1.6001e-05 5 1.7e-05 5 1.7001e-05 -5 1.8e-05 -5 1.8001e-05 -5 1.9e-05 -5 1.9001e-05 0 2e-05 0 2.0001e-05 0 2.1e-05 0 2.1001e-05 0 2.2e-05 0 2.2001e-05 -5)
Vin1 tf_615b305d 0 PWL(0 0 1e-06 0 1.001e-06 -5 2e-06 -5 2.001e-06 5 3e-06 5 3.001e-06 -5 4e-06 -5 4.001e-06 5 5e-06 5 5.001e-06 -5 6e-06 -5 6.001e-06 5 7e-06 5 7.001e-06 -5 8e-06 -5 8.001e-06 5 9e-06 5 9.001e-06 5 1e-05 5 1.0001e-05 -5 1.1e-05 -5 1.1001e-05 5 1.2e-05 5 1.2001e-05 -5 1.3e-05 -5 1.3001e-05 -5 1.4e-05 -5 1.4001e-05 5 1.5e-05 5 1.5001e-05 5 1.6e-05 5 1.6001e-05 -5 1.7e-05 -5 1.7001e-05 0 1.8e-05 0 1.8001e-05 0 1.9e-05 0 1.9001e-05 -5 2e-05 -5 2.0001e-05 5 2.1e-05 5 2.1001e-05 0 2.2e-05 0 2.2001e-05 0)
Vin2 tf_625b315d 0 PWL(0 0 1e-06 0 1.001e-06 -5 2e-06 -5 2.001e-06 -5 3e-06 -5 3.001e-06 0 4e-06 0 4.001e-06 5 5e-06 5 5.001e-06 5 6e-06 5 6.001e-06 5 7e-06 5 7.001e-06 0 8e-06 0 8.001e-06 -5 9e-06 -5 9.001e-06 0 1e-05 0 1.0001e-05 -5 1.1e-05 -5 1.1001e-05 5 1.2e-05 5 1.2001e-05 5 1.3e-05 5 1.3001e-05 -5 1.4e-05 -5 1.4001e-05 -5 1.5e-05 -5 1.5001e-05 5 1.6e-05 5 1.6001e-05 -5 1.7e-05 -5 1.7001e-05 0 1.8e-05 0 1.8001e-05 0 1.9e-05 0 1.9001e-05 0 2e-05 0 2.0001e-05 0 2.1e-05 0 2.1001e-05 5 2.2e-05 5 2.2001e-05 0)
Vin3 tf_625b305d 0 PWL(0 0 1e-06 0 1.001e-06 0 2e-06 0 2.001e-06 -5 3e-06 -5 3.001e-06 0 4e-06 0 4.001e-06 -5 5e-06 -5 5.001e-06 0 6e-06 0 6.001e-06 -5 7e-06 -5 7.001e-06 0 8e-06 0 8.001e-06 -5 9e-06 -5 9.001e-06 -5 1e-05 -5 1.0001e-05 0 1.1e-05 0 1.1001e-05 -5 1.2e-05 -5 1.2001e-05 0 1.3e-05 0 1.3001e-05 5 1.4e-05 5 1.4001e-05 0 1.5e-05 0 1.5001e-05 -5 1.6e-05 -5 1.6001e-05 0 1.7e-05 0 1.7001e-05 0 1.8e-05 0 1.8001e-05 -5 1.9e-05 -5 1.9001e-05 5 2e-05 5 2.0001e-05 5 2.1e-05 5 2.1001e-05 0 2.2e-05 0 2.2001e-05 -5)
Vin4 cin 0 PWL(0 0 1e-06 0 1.001e-06 5 2e-06 5 2.001e-06 -5 3e-06 -5 3.001e-06 0 4e-06 0 4.001e-06 5 5e-06 5 5.001e-06 0 6e-06 0 6.001e-06 -5 7e-06 -5 7.001e-06 0 8e-06 0 8.001e-06 -5 9e-06 -5 9.001e-06 5 1e-05 5 1.0001e-05 -5 1.1e-05 -5 1.1001e-05 5 1.2e-05 5 1.2001e-05 -5 1.3e-05 -5 1.3001e-05 -5 1.4e-05 -5 1.4001e-05 0 1.5e-05 0 1.5001e-05 -5 1.6e-05 -5 1.6001e-05 -5 1.7e-05 -5 1.7001e-05 0 1.8e-05 0 1.8001e-05 -5 1.9e-05 -5 1.9001e-05 -5 2e-05 -5 2.0001e-05 -5 2.1e-05 -5 2.1001e-05 0 2.2e-05 0 2.2001e-05 -5)
Cload0 tf_73756d5b315d 0 1e-14
Cload1 tf_73756d5b305d 0 1e-14
Cload2 cout 0 1e-14
.nodeset v(tf_73756d5b315d)=0
.nodeset v(tf_73756d5b305d)=0
.nodeset v(cout)=0
.nodeset v(xdut.n_ex_I91)=0
.nodeset v(xdut.n_ex_I146)=0
.nodeset v(xdut.n_ex_I143)=0
.nodeset v(xdut.n_ex_I105)=0
.nodeset v(xdut.n_ex_I106)=0
.nodeset v(xdut.n_ex_I108)=0
.nodeset v(xdut.n_ex_I92)=0
.nodeset v(xdut.n_ex_I87)=0
.nodeset v(xdut.n_ex_I128)=0
.nodeset v(xdut.n_ex_I127)=0
.nodeset v(xdut.n_ex_I138)=0
.nodeset v(xdut.n_ex_I137)=0
.nodeset v(xdut.n_ex_I134)=0
.nodeset v(xdut.n_ex_I132)=0
.nodeset v(xdut.n_ex_I144)=0
.nodeset v(xdut.n_ex_I142)=0
.nodeset v(xdut.n_ex_I100)=0
.nodeset v(xdut.n_ex_I97)=0
.nodeset v(xdut.n_ex_I90)=0
.nodeset v(xdut.n_ex_I130)=0
.nodeset v(xdut.n_ex_I131)=0
.nodeset v(xdut.n_ex_I140)=0
.nodeset v(xdut.n_ex_I141)=0
.nodeset v(xdut.n_ex_I101)=0
.nodeset v(xdut.n_ex_I104)=0
.nodeset v(xdut.n_ex_I95)=0
.nodeset v(xdut.n_ex_I129)=0
.nodeset v(xdut.n_ex_I135)=0
.nodeset v(xdut.n_ex_I139)=0

.control
set noaskquit
set wr_singlescale
set wr_vecnames
set numdgt=15
tran 2.5e-10 2.3e-05 0 2.5e-10
wrdata waveform.txt v("sum[1]") v("sum[0]") v(cout)
quit
.endc
.end
