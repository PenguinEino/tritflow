TritFlow ternary testbench
*
.parameters vthMP	= 0
.parameters vthMN 	= 0
.parameters vthMPE      = 0
.parameters vthMNE      = 0
.parameters magRR       = 1
.parameters magRS       = 1
.parameters magCSIO     = 1
.include "/home/ishi-kai/pdk/TR-1um-pinned/libs.tech/spice/models/models_IP62_cap_v5p1.lib"
.include "/home/ishi-kai/pdk/TR-1um-pinned/libs.tech/spice/models/models_IP62_diode_v2.lib"
.include "/home/ishi-kai/pdk/TR-1um-pinned/libs.tech/spice/models/models_IP62_mos_v2.lib"
.include "/home/ishi-kai/pdk/TR-1um-pinned/libs.tech/spice/models/models_IP62_res_v5.lib"
* PDK extraction; public ports normalized, no parasitic RC
.subckt NAND A B Y VDD VMID VSS
* device instance $1 r0 *1 26,100 PMOS
XM_ex_1 n_ex_4 A VDD VDD PMOS L=1u W=19u AS=53.2p AD=53.2p PS=43.6u PD=43.6u
* device instance $2 r0 *1 41,100 PMOS
XM_ex_2 n_ex_4 B VDD VDD PMOS L=1u W=19u AS=53.2p AD=53.2p PS=43.6u PD=43.6u
* device instance $3 r0 *1 26,28 NMOS
XM_ex_3 n_ex_18 A n_ex_6 VSS NMOS L=1u W=13u AS=36.4p AD=36.4p PS=31.6u PD=31.6u
* device instance $4 r0 *1 41,28 NMOS
XM_ex_4 VSS B n_ex_18 VSS NMOS L=1u W=13u AS=36.4p AD=36.4p PS=31.6u PD=31.6u
* device instance $5 r0 *1 96,54 F_RR
XR_ex_5 n_ex_6 Y VDD F_RR R=10.7142857143 L=30u W=2.8u A=84p P=65.6u m=1
* device instance $6 r0 *1 96,84 F_RR
XR_ex_6 n_ex_4 Y VDD F_RR R=10.7142857143 L=30u W=2.8u A=84p P=65.6u m=1

.ends NAND

.temp 27
.options rshunt=1e12
VDD VDD 0 5
VMID VMID 0 0
VSS VSS 0 -5
Xdut A B Y VDD VMID VSS NAND
Vin0 A 0 PWL(0 -5 4.0025e-07 -5 4.005e-07 5 8.005e-07 5 8.0075e-07 5 1.20075e-06 5 1.201e-06 5 1.601e-06 5 1.60125e-06 5 2.00125e-06 5 2.0015e-06 5 2.4015e-06 5 2.40175e-06 0 2.80175e-06 0 2.802e-06 5 3.202e-06 5 3.20225e-06 0 3.60225e-06 0 3.6025e-06 5 4.0025e-06 5 4.00275e-06 0 4.40275e-06 0 4.403e-06 5 4.803e-06 5 4.80325e-06 -5 5.20325e-06 -5 5.2035e-06 5 5.6035e-06 5 5.60375e-06 -5 6.00375e-06 -5 6.004e-06 5 6.404e-06 5 6.40425e-06 -5 6.80425e-06 -5 6.8045e-06 5 7.2045e-06 5 7.20475e-06 5 7.60475e-06 5 7.605e-06 5 8.005e-06 5 8.00525e-06 0 8.40525e-06 0 8.4055e-06 5 8.8055e-06 5 8.80575e-06 0 9.20575e-06 0 9.206e-06 5 9.606e-06 5 9.60625e-06 0 1.000625e-05 0 1.00065e-05 5 1.04065e-05 5 1.040675e-05 -5 1.080675e-05 -5 1.0807e-05 5 1.1207e-05 5 1.120725e-05 -5 1.160725e-05 -5 1.16075e-05 5 1.20075e-05 5 1.200775e-05 -5 1.240775e-05 -5 1.2408e-05 5 1.2808e-05 5 1.280825e-05 0 1.320825e-05 0 1.32085e-05 5 1.36085e-05 5 1.360875e-05 0 1.400875e-05 0 1.4009e-05 5 1.4409e-05 5 1.440925e-05 0 1.480925e-05 0 1.48095e-05 5 1.52095e-05 5 1.520975e-05 -5 1.560975e-05 -5 1.561e-05 5 1.601e-05 5 1.601025e-05 -5 1.641025e-05 -5 1.64105e-05 5 1.68105e-05 5 1.681075e-05 -5 1.721075e-05 -5 1.7211e-05 0 1.7611e-05 0 1.761125e-05 0 1.801125e-05 0 1.80115e-05 0 1.84115e-05 0 1.841175e-05 0 1.881175e-05 0 1.8812e-05 0 1.9212e-05 0 1.921225e-05 -5 1.961225e-05 -5 1.96125e-05 0 2.00125e-05 0 2.001275e-05 -5 2.041275e-05 -5 2.0413e-05 0 2.0813e-05 0 2.081325e-05 -5 2.121325e-05 -5 2.12135e-05 0 2.16135e-05 0 2.161375e-05 0 2.201375e-05 0 2.2014e-05 0 2.2414e-05 0 2.241425e-05 -5 2.281425e-05 -5 2.28145e-05 0 2.32145e-05 0 2.321475e-05 -5 2.361475e-05 -5 2.3615e-05 0 2.4015e-05 0 2.401525e-05 -5 2.441525e-05 -5 2.44155e-05 0 2.48155e-05 0 2.481575e-05 -5 2.521575e-05 -5 2.5216e-05 0 2.5616e-05 0 2.561625e-05 -5 2.601625e-05 -5 2.60165e-05 0 2.64165e-05 0 2.641675e-05 -5 2.681675e-05 -5 2.6817e-05 -5 2.7217e-05 -5 2.721725e-05 -5 2.761725e-05 -5 2.76175e-05 -5 2.80175e-05 -5 2.801775e-05 -5 2.841775e-05 -5 2.8418e-05 -5 2.8818e-05 -5 2.881825e-05 -5)
Vin1 B 0 PWL(0 -5 4.0025e-07 -5 4.005e-07 5 8.005e-07 5 8.0075e-07 0 1.20075e-06 0 1.201e-06 5 1.601e-06 5 1.60125e-06 -5 2.00125e-06 -5 2.0015e-06 5 2.4015e-06 5 2.40175e-06 5 2.80175e-06 5 2.802e-06 5 3.202e-06 5 3.20225e-06 0 3.60225e-06 0 3.6025e-06 5 4.0025e-06 5 4.00275e-06 -5 4.40275e-06 -5 4.403e-06 5 4.803e-06 5 4.80325e-06 5 5.20325e-06 5 5.2035e-06 5 5.6035e-06 5 5.60375e-06 0 6.00375e-06 0 6.004e-06 5 6.404e-06 5 6.40425e-06 -5 6.80425e-06 -5 6.8045e-06 0 7.2045e-06 0 7.20475e-06 -5 7.60475e-06 -5 7.605e-06 0 8.005e-06 0 8.00525e-06 5 8.40525e-06 5 8.4055e-06 0 8.8055e-06 0 8.80575e-06 0 9.20575e-06 0 9.206e-06 0 9.606e-06 0 9.60625e-06 -5 1.000625e-05 -5 1.00065e-05 0 1.04065e-05 0 1.040675e-05 5 1.080675e-05 5 1.0807e-05 0 1.1207e-05 0 1.120725e-05 0 1.160725e-05 0 1.16075e-05 0 1.20075e-05 0 1.200775e-05 -5 1.240775e-05 -5 1.2408e-05 -5 1.2808e-05 -5 1.280825e-05 5 1.320825e-05 5 1.32085e-05 -5 1.36085e-05 -5 1.360875e-05 0 1.400875e-05 0 1.4009e-05 -5 1.4409e-05 -5 1.440925e-05 -5 1.480925e-05 -5 1.48095e-05 -5 1.52095e-05 -5 1.520975e-05 5 1.560975e-05 5 1.561e-05 -5 1.601e-05 -5 1.601025e-05 0 1.641025e-05 0 1.64105e-05 -5 1.68105e-05 -5 1.681075e-05 -5 1.721075e-05 -5 1.7211e-05 5 1.7611e-05 5 1.761125e-05 0 1.801125e-05 0 1.80115e-05 5 1.84115e-05 5 1.841175e-05 -5 1.881175e-05 -5 1.8812e-05 5 1.9212e-05 5 1.921225e-05 5 1.961225e-05 5 1.96125e-05 5 2.00125e-05 5 2.001275e-05 0 2.041275e-05 0 2.0413e-05 5 2.0813e-05 5 2.081325e-05 -5 2.121325e-05 -5 2.12135e-05 0 2.16135e-05 0 2.161375e-05 -5 2.201375e-05 -5 2.2014e-05 0 2.2414e-05 0 2.241425e-05 5 2.281425e-05 5 2.28145e-05 0 2.32145e-05 0 2.321475e-05 0 2.361475e-05 0 2.3615e-05 0 2.4015e-05 0 2.401525e-05 -5 2.441525e-05 -5 2.44155e-05 -5 2.48155e-05 -5 2.481575e-05 5 2.521575e-05 5 2.5216e-05 -5 2.5616e-05 -5 2.561625e-05 0 2.601625e-05 0 2.60165e-05 -5 2.64165e-05 -5 2.641675e-05 -5 2.681675e-05 -5 2.6817e-05 5 2.7217e-05 5 2.721725e-05 0 2.761725e-05 0 2.76175e-05 5 2.80175e-05 5 2.801775e-05 -5 2.841775e-05 -5 2.8418e-05 0 2.8818e-05 0 2.881825e-05 -5)
Cload0 Y 0 1e-14
.nodeset v(Y)=5
.nodeset v(xdut.n_ex_4)=5
.nodeset v(xdut.n_ex_18)=-5
.nodeset v(xdut.n_ex_6)=-5
.control
set noaskquit
set wr_singlescale
set wr_vecnames
set numdgt=15
tran 2.5e-11 2.921825e-05 0 2.5e-11
wrdata waveform.txt v(A) v(B) v(Y) i(vdd) i(vmid) i(vss)
quit
.endc
.end
