TritFlow ternary testbench
*
.parameters vthMP	= 0
.parameters vthMN 	= 0
.parameters vthMPE      = 0
.parameters vthMNE      = 0
.parameters magRR       = 1
.parameters magRS       = 1
.parameters magCSIO     = 1
.include "/home/penguin/tritflow-sim/runtime/native/TR-1um-5d963db9d44e192d37a0489c208bfccf2e2f690c/libs.tech/spice/models/models_IP62_cap_v5p1.lib"
.include "/home/penguin/tritflow-sim/runtime/native/TR-1um-5d963db9d44e192d37a0489c208bfccf2e2f690c/libs.tech/spice/models/models_IP62_diode_v2.lib"
.include "/home/penguin/tritflow-sim/runtime/native/TR-1um-5d963db9d44e192d37a0489c208bfccf2e2f690c/libs.tech/spice/models/models_IP62_mos_v2.lib"
.include "/home/penguin/tritflow-sim/runtime/native/TR-1um-5d963db9d44e192d37a0489c208bfccf2e2f690c/libs.tech/spice/models/models_IP62_res_v5.lib"
* PDK extraction; public ports normalized, no parasitic RC
.subckt NANY A B Y VDD VMID VSS
* device instance $1 r0 *1 56,100 PMOS
XM_ex_1 n_ex_7 A Y VDD PMOS L=1u W=14u AS=39.2p AD=39.2p PS=33.6u PD=33.6u
* device instance $2 r0 *1 71,100 PMOS
XM_ex_2 n_ex_9 B Y VDD PMOS L=1u W=14u AS=39.2p AD=39.2p PS=33.6u PD=33.6u
* device instance $3 r0 *1 41,100 PMOS
XM_ex_3 n_ex_30 B n_ex_43 VDD PMOS L=1u W=34u AS=95.2p AD=95.2p PS=73.6u PD=73.6u
* device instance $4 r0 *1 26,100 PMOS
XM_ex_4 n_ex_43 A VDD VDD PMOS L=1u W=34u AS=95.2p AD=95.2p PS=73.6u PD=73.6u
* device instance $5 r0 *1 56,27 NMOS
XM_ex_5 n_ex_7 B VMID VSS NMOS L=1u W=8u AS=22.4p AD=22.4p PS=21.6u PD=21.6u
* device instance $6 r0 *1 71,27 NMOS
XM_ex_6 n_ex_9 A VMID VSS NMOS L=1u W=8u AS=22.4p AD=22.4p PS=21.6u PD=21.6u
* device instance $7 r0 *1 26,27 NMOS
XM_ex_7 n_ex_17 A n_ex_5 VSS NMOS L=1u W=11u AS=30.8p AD=30.8p PS=27.6u PD=27.6u
* device instance $8 r0 *1 41,27 NMOS
XM_ex_8 VSS B n_ex_17 VSS NMOS L=1u W=11u AS=30.8p AD=30.8p PS=27.6u PD=27.6u
* device instance $9 r0 *1 118.5,54 F_RR
XR_ex_9 n_ex_5 Y VDD F_RR R=10.7142857143 L=30u W=2.8u A=84p P=65.6u m=1
* device instance $10 r0 *1 118.5,84 F_RR
XR_ex_10 n_ex_30 Y VDD F_RR R=10.7142857143 L=30u W=2.8u A=84p P=65.6u m=1

.ends NANY

.temp 27
.options rshunt=1e12
VDD VDD 0 5
VMID VMID 0 0
VSS VSS 0 -5
Xdut A B Y VDD VMID VSS NANY
Vin0 A 0 DC -5 PWL(0 -5 4.5e-07 -5 6.5e-07 5 9e-07 5 1.1e-06 5 1.35e-06 5 1.55e-06 5 1.8e-06 5 2e-06 5 2.25e-06 5 2.45e-06 5 2.7e-06 5 2.9e-06 0 3.15e-06 0 3.35e-06 5 3.6e-06 5 3.8e-06 0 4.05e-06 0 4.25e-06 5 4.5e-06 5 4.7e-06 0 4.95e-06 0 5.15e-06 5 5.4e-06 5 5.6e-06 -5 5.85e-06 -5 6.05e-06 5 6.3e-06 5 6.5e-06 -5 6.75e-06 -5 6.95e-06 5 7.2e-06 5 7.4e-06 -5 7.65e-06 -5 7.85e-06 5 8.1e-06 5 8.3e-06 5 8.55e-06 5 8.75e-06 5 9e-06 5 9.2e-06 0 9.45e-06 0 9.65e-06 5 9.9e-06 5 1.01e-05 0 1.035e-05 0 1.055e-05 5 1.08e-05 5 1.1e-05 0 1.125e-05 0 1.145e-05 5 1.17e-05 5 1.19e-05 -5 1.215e-05 -5 1.235e-05 5 1.26e-05 5 1.28e-05 -5 1.305e-05 -5 1.325e-05 5 1.35e-05 5 1.37e-05 -5 1.395e-05 -5 1.415e-05 5 1.44e-05 5 1.46e-05 0 1.485e-05 0 1.505e-05 5 1.53e-05 5 1.55e-05 0 1.575e-05 0 1.595e-05 5 1.62e-05 5 1.64e-05 0 1.665e-05 0 1.685e-05 5 1.71e-05 5 1.73e-05 -5 1.755e-05 -5 1.775e-05 5 1.8e-05 5 1.82e-05 -5 1.845e-05 -5 1.865e-05 5 1.89e-05 5 1.91e-05 -5 1.935e-05 -5 1.955e-05 0 1.98e-05 0 2e-05 0 2.025e-05 0 2.045e-05 0 2.07e-05 0 2.09e-05 0 2.115e-05 0 2.135e-05 0 2.16e-05 0 2.18e-05 -5 2.205e-05 -5 2.225e-05 0 2.25e-05 0 2.27e-05 -5 2.295e-05 -5 2.315e-05 0 2.34e-05 0 2.36e-05 -5 2.385e-05 -5 2.405e-05 0 2.43e-05 0 2.45e-05 0 2.475e-05 0 2.495e-05 0 2.52e-05 0 2.54e-05 -5 2.565e-05 -5 2.585e-05 0 2.61e-05 0 2.63e-05 -5 2.655e-05 -5 2.675e-05 0 2.7e-05 0 2.72e-05 -5 2.745e-05 -5 2.765e-05 0 2.79e-05 0 2.81e-05 -5 2.835e-05 -5 2.855e-05 0 2.88e-05 0 2.9e-05 -5 2.925e-05 -5 2.945e-05 0 2.97e-05 0 2.99e-05 -5 3.015e-05 -5 3.035e-05 -5 3.06e-05 -5 3.08e-05 -5 3.105e-05 -5 3.125e-05 -5 3.15e-05 -5 3.17e-05 -5 3.195e-05 -5 3.215e-05 -5 3.24e-05 -5 3.26e-05 -5)
Vin1 B 0 DC -5 PWL(0 -5 4.5e-07 -5 6.5e-07 5 9e-07 5 1.1e-06 0 1.35e-06 0 1.55e-06 5 1.8e-06 5 2e-06 -5 2.25e-06 -5 2.45e-06 5 2.7e-06 5 2.9e-06 5 3.15e-06 5 3.35e-06 5 3.6e-06 5 3.8e-06 0 4.05e-06 0 4.25e-06 5 4.5e-06 5 4.7e-06 -5 4.95e-06 -5 5.15e-06 5 5.4e-06 5 5.6e-06 5 5.85e-06 5 6.05e-06 5 6.3e-06 5 6.5e-06 0 6.75e-06 0 6.95e-06 5 7.2e-06 5 7.4e-06 -5 7.65e-06 -5 7.85e-06 0 8.1e-06 0 8.3e-06 -5 8.55e-06 -5 8.75e-06 0 9e-06 0 9.2e-06 5 9.45e-06 5 9.65e-06 0 9.9e-06 0 1.01e-05 0 1.035e-05 0 1.055e-05 0 1.08e-05 0 1.1e-05 -5 1.125e-05 -5 1.145e-05 0 1.17e-05 0 1.19e-05 5 1.215e-05 5 1.235e-05 0 1.26e-05 0 1.28e-05 0 1.305e-05 0 1.325e-05 0 1.35e-05 0 1.37e-05 -5 1.395e-05 -5 1.415e-05 -5 1.44e-05 -5 1.46e-05 5 1.485e-05 5 1.505e-05 -5 1.53e-05 -5 1.55e-05 0 1.575e-05 0 1.595e-05 -5 1.62e-05 -5 1.64e-05 -5 1.665e-05 -5 1.685e-05 -5 1.71e-05 -5 1.73e-05 5 1.755e-05 5 1.775e-05 -5 1.8e-05 -5 1.82e-05 0 1.845e-05 0 1.865e-05 -5 1.89e-05 -5 1.91e-05 -5 1.935e-05 -5 1.955e-05 5 1.98e-05 5 2e-05 0 2.025e-05 0 2.045e-05 5 2.07e-05 5 2.09e-05 -5 2.115e-05 -5 2.135e-05 5 2.16e-05 5 2.18e-05 5 2.205e-05 5 2.225e-05 5 2.25e-05 5 2.27e-05 0 2.295e-05 0 2.315e-05 5 2.34e-05 5 2.36e-05 -5 2.385e-05 -5 2.405e-05 0 2.43e-05 0 2.45e-05 -5 2.475e-05 -5 2.495e-05 0 2.52e-05 0 2.54e-05 5 2.565e-05 5 2.585e-05 0 2.61e-05 0 2.63e-05 0 2.655e-05 0 2.675e-05 0 2.7e-05 0 2.72e-05 -5 2.745e-05 -5 2.765e-05 -5 2.79e-05 -5 2.81e-05 5 2.835e-05 5 2.855e-05 -5 2.88e-05 -5 2.9e-05 0 2.925e-05 0 2.945e-05 -5 2.97e-05 -5 2.99e-05 -5 3.015e-05 -5 3.035e-05 5 3.06e-05 5 3.08e-05 0 3.105e-05 0 3.125e-05 5 3.15e-05 5 3.17e-05 -5 3.195e-05 -5 3.215e-05 0 3.24e-05 0 3.26e-05 -5)
Cload0 Y 0 1e-12
.nodeset v(Y)=5
.nodeset v(xdut.n_ex_7)=0
.nodeset v(xdut.n_ex_9)=0
.nodeset v(xdut.n_ex_30)=5
.nodeset v(xdut.n_ex_43)=5
.nodeset v(xdut.n_ex_17)=-5
.nodeset v(xdut.n_ex_5)=-5
.control
set noaskquit
set wr_singlescale
set wr_vecnames
set numdgt=15
tran 2.5e-10 3.285e-05 0 2.5e-10
wrdata waveform.txt v(A) v(B) v(Y) i(vdd) i(vmid) i(vss)
quit
.endc
.end
