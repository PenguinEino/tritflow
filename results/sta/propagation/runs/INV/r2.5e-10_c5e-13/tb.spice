TritFlow ternary testbench
*
.parameters vthMP	= 0
.parameters vthMN 	= 0
.parameters vthMPE      = 0
.parameters vthMNE      = 0
.parameters magRR       = 1
.parameters magRS       = 1
.parameters magCSIO     = 1
.include "/home/penguin/tritflow-sim/runtime/native/TR-1um-5d963db9d44e192d37a0489c208bfccf2e2f690c/libs.tech/spice/models/models_IP62_cap_v5p1.lib"
.include "/home/penguin/tritflow-sim/runtime/native/TR-1um-5d963db9d44e192d37a0489c208bfccf2e2f690c/libs.tech/spice/models/models_IP62_diode_v2.lib"
.include "/home/penguin/tritflow-sim/runtime/native/TR-1um-5d963db9d44e192d37a0489c208bfccf2e2f690c/libs.tech/spice/models/models_IP62_mos_v2.lib"
.include "/home/penguin/tritflow-sim/runtime/native/TR-1um-5d963db9d44e192d37a0489c208bfccf2e2f690c/libs.tech/spice/models/models_IP62_res_v5.lib"
* PDK extraction; public ports normalized, no parasitic RC
.subckt INV A Y VDD VMID VSS
* device instance $1 r0 *1 19.2,56 PMOS
XM_ex_1 n_ex_5 A VDD VDD PMOS L=1u W=13.5u AS=37.8p AD=37.8p PS=32.6u PD=32.6u
* device instance $2 r0 *1 19.2,26 NMOS
XM_ex_2 n_ex_6 A VSS VSS NMOS L=1u W=5u AS=14p AD=14p PS=15.6u PD=15.6u
* device instance $3 r0 *1 70,44 F_RR
XR_ex_3 n_ex_6 Y VDD F_RR R=10.7142857143 L=30u W=2.8u A=84p P=65.6u m=1
* device instance $4 r0 *1 70,57 F_RR
XR_ex_4 n_ex_5 Y VDD F_RR R=10.7142857143 L=30u W=2.8u A=84p P=65.6u m=1

.ends INV

.temp 27
.options rshunt=1e12
VDD VDD 0 5
VMID VMID 0 0
VSS VSS 0 -5
Xdut A Y VDD VMID VSS INV
Vin0 A 0 DC -5 PWL(0 -5 2.5025e-07 -5 2.505e-07 5 5.005e-07 5 5.0075e-07 0 7.5075e-07 0 7.51e-07 5 1.001e-06 5 1.00125e-06 -5 1.25125e-06 -5 1.2515e-06 0 1.5015e-06 0 1.50175e-06 -5)
Cload0 Y 0 5e-13
.nodeset v(Y)=5
.nodeset v(xdut.n_ex_5)=5
.nodeset v(xdut.n_ex_6)=-5
.control
set noaskquit
set wr_singlescale
set wr_vecnames
set numdgt=15
tran 2.5e-10 1.75175e-06 0 2.5e-10
wrdata waveform.txt v(A) v(Y) i(vdd) i(vmid) i(vss)
quit
.endc
.end
