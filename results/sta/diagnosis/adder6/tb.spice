TritFlow ternary testbench
*
.parameters vthMP	= 0
.parameters vthMN 	= 0
.parameters vthMPE      = 0
.parameters vthMNE      = 0
.parameters magRR       = 1
.parameters magRS       = 1
.parameters magCSIO     = 1
.include "/home/penguin/tritflow-sim/runtime/native/TR-1um-5d963db9d44e192d37a0489c208bfccf2e2f690c/libs.tech/spice/models/models_IP62_cap_v5p1.lib"
.include "/home/penguin/tritflow-sim/runtime/native/TR-1um-5d963db9d44e192d37a0489c208bfccf2e2f690c/libs.tech/spice/models/models_IP62_diode_v2.lib"
.include "/home/penguin/tritflow-sim/runtime/native/TR-1um-5d963db9d44e192d37a0489c208bfccf2e2f690c/libs.tech/spice/models/models_IP62_mos_v2.lib"
.include "/home/penguin/tritflow-sim/runtime/native/TR-1um-5d963db9d44e192d37a0489c208bfccf2e2f690c/libs.tech/spice/models/models_IP62_res_v5.lib"
* net tf_615b305d = a[0]
* net tf_615b315d = a[1]
* net tf_615b325d = a[2]
* net tf_615b335d = a[3]
* net tf_615b345d = a[4]
* net tf_615b355d = a[5]
* net tf_625b305d = b[0]
* net tf_625b315d = b[1]
* net tf_625b325d = b[2]
* net tf_625b335d = b[3]
* net tf_625b345d = b[4]
* net tf_625b355d = b[5]
* net tf_73756d5b305d = sum[0]
* net tf_73756d5b315d = sum[1]
* net tf_73756d5b325d = sum[2]
* net tf_73756d5b335d = sum[3]
* net tf_73756d5b345d = sum[4]
* net tf_73756d5b355d = sum[5]
* Created by KLayout
*** My special header ***

* cell adder6
* pin VDD
* pin VMID
* pin tf_615b355d
* pin tf_615b345d
* pin tf_615b335d
* pin tf_615b325d
* pin tf_615b315d
* pin tf_615b305d
* pin tf_625b355d
* pin tf_625b345d
* pin tf_625b335d
* pin tf_625b325d
* pin tf_625b315d
* pin tf_625b305d
* pin tf_73756d5b355d
* pin tf_73756d5b345d
* pin tf_73756d5b335d
* pin tf_73756d5b325d
* pin tf_73756d5b315d
* pin tf_73756d5b305d
* pin cin
* pin cout
* pin VSS
.SUBCKT adder6 VDD VMID tf_615b355d tf_615b345d tf_615b335d tf_615b325d tf_615b315d tf_615b305d tf_625b355d tf_625b345d tf_625b335d tf_625b325d tf_625b315d tf_625b305d tf_73756d5b355d tf_73756d5b345d tf_73756d5b335d tf_73756d5b325d tf_73756d5b315d tf_73756d5b305d cin cout VSS
* cell instance $1 r0 *1 102,66
X_ex_1 VDD tf_615b305d n_ex_I251 VSS INV
* cell instance $2 m90 *1 378,66
X_ex_2 VMID cin n_ex_I383 VDD n_ex_I449 VSS NANY
* cell instance $4 r0 *1 72,270
X_ex_4 VMID tf_625b305d tf_615b305d VDD n_ex_I405 VSS NANY
* cell instance $5 r0 *1 240,270
X_ex_5 VMID n_ex_I405 tf_625b305d VDD n_ex_I404 VSS NANY
* cell instance $6 r0 *1 102,474
X_ex_6 VDD n_ex_I208 n_ex_I238 VSS INV
* cell instance $7 m90 *1 378,474
X_ex_7 VMID n_ex_I449 cin VDD n_ex_I425 VSS NANY
* cell instance $8 m90 *1 270,678
X_ex_8 VMID tf_625b315d tf_615b315d VDD n_ex_I426 VSS NANY
* cell instance $9 m90 *1 378,678
X_ex_9 VDD n_ex_I219 n_ex_I249 VSS INV
* cell instance $10 m90 *1 270,882
X_ex_10 VMID n_ex_I295 n_ex_I361 VDD n_ex_I427 VSS NANY
* cell instance $11 m90 *1 378,882
X_ex_11 VDD n_ex_I427 n_ex_I248 VSS INV
* cell instance $12 r0 *1 72,1086
X_ex_12 VMID tf_625b325d tf_615b325d VDD n_ex_I401 VSS NANY
* cell instance $13 m90 *1 408,1086
X_ex_13 VMID n_ex_I296 n_ex_I362 VDD n_ex_I428 VSS NANY
* cell instance $14 m90 *1 240,1290
X_ex_14 VMID n_ex_I361 tf_625b335d VDD n_ex_I429 VSS NANY
* cell instance $15 m90 *1 408,1290
X_ex_15 VMID tf_625b335d tf_615b335d VDD n_ex_I361 VSS NANY
* cell instance $16 r0 *1 102,1494
X_ex_16 VDD tf_615b325d n_ex_I362 VSS INV
* cell instance $17 r0 *1 210,1494
X_ex_17 VMID n_ex_I428 n_ex_I401 VDD n_ex_I402 VSS NANY
* cell instance $18 m90 *1 210,1698
X_ex_18 VDD tf_615b345d n_ex_I246 VSS INV
* cell instance $19 m90 *1 378,1698
X_ex_19 VMID n_ex_I299 n_ex_I365 VDD n_ex_I219 VSS NANY
* cell instance $20 m90 *1 240,1902
X_ex_20 VMID n_ex_I300 n_ex_I366 VDD n_ex_I432 VSS NANY
* cell instance $21 m90 *1 408,1902
X_ex_21 VMID tf_625b345d tf_615b345d VDD n_ex_I433 VSS NANY
* cell instance $22 r0 *1 132,2106
X_ex_22 VDD n_ex_I196 n_ex_I226 VSS INV
* cell instance $23 r0 *1 240,2106
X_ex_23 VDD n_ex_I195 n_ex_I225 VSS INV
* cell instance $24 m90 *1 270,2310
X_ex_24 VMID n_ex_I302 n_ex_I368 VDD tf_73756d5b335d VSS NANY
* cell instance $25 r0 *1 270,2310
X_ex_25 VDD tf_615b315d n_ex_I366 VSS INV
* cell instance $26 m90 *1 654,66
X_ex_26 VMID n_ex_I303 n_ex_I369 VDD tf_73756d5b345d VSS NANY
* cell instance $27 m90 *1 822,66
X_ex_27 VMID n_ex_I238 n_ex_I370 VDD n_ex_I436 VSS NANY
* cell instance $28 m90 *1 654,270
X_ex_28 VMID n_ex_I426 tf_625b315d VDD n_ex_I300 VSS NANY
* cell instance $29 r0 *1 654,270
X_ex_29 VMID n_ex_I404 n_ex_I251 VDD n_ex_I408 VSS NANY
* cell instance $30 r0 *1 486,474
X_ex_30 VMID n_ex_I401 tf_625b325d VDD n_ex_I296 VSS NANY
* cell instance $31 r0 *1 654,474
X_ex_31 VMID n_ex_I436 n_ex_I238 VDD n_ex_I409 VSS NANY
* cell instance $32 r0 *1 486,678
X_ex_32 VMID n_ex_I408 n_ex_I405 VDD n_ex_I410 VSS NANY
* cell instance $33 m90 *1 822,678
X_ex_33 VMID n_ex_I409 n_ex_I372 VDD n_ex_I302 VSS NANY
* cell instance $34 r0 *1 486,882
X_ex_34 VMID n_ex_I433 tf_625b345d VDD n_ex_I412 VSS NANY
* cell instance $35 r0 *1 654,882
X_ex_35 VMID n_ex_I302 n_ex_I295 VDD n_ex_I413 VSS NANY
* cell instance $36 r0 *1 516,1086
X_ex_36 VDD tf_615b335d n_ex_I236 VSS INV
* cell instance $37 r0 *1 624,1086
X_ex_37 VMID n_ex_I302 n_ex_I436 VDD n_ex_I414 VSS NANY
* cell instance $38 m90 *1 684,1290
X_ex_38 VMID n_ex_I295 n_ex_I248 VDD n_ex_I370 VSS NANY
* cell instance $39 r0 *1 684,1290
X_ex_39 VDD n_ex_I413 n_ex_I234 VSS INV
* cell instance $40 m90 *1 654,1494
X_ex_40 VDD n_ex_I213 n_ex_I243 VSS INV
* cell instance $41 m90 *1 762,1494
X_ex_41 VDD n_ex_I414 n_ex_I368 VSS INV
* cell instance $42 m90 *1 654,1698
X_ex_42 VMID n_ex_I365 n_ex_I374 VDD n_ex_I440 VSS NANY
* cell instance $43 m90 *1 822,1698
X_ex_43 VMID n_ex_I309 n_ex_I243 VDD n_ex_I441 VSS NANY
* cell instance $44 m90 *1 654,1902
X_ex_44 VMID n_ex_I429 n_ex_I236 VDD n_ex_I295 VSS NANY
* cell instance $45 m90 *1 822,1902
X_ex_45 VMID tf_625b355d tf_615b355d VDD n_ex_I443 VSS NANY
* cell instance $46 r0 *1 486,2106
X_ex_46 VMID n_ex_I412 n_ex_I246 VDD n_ex_I417 VSS NANY
* cell instance $47 m90 *1 822,2106
X_ex_47 VMID n_ex_I432 n_ex_I226 VDD n_ex_I195 VSS NANY
* cell instance $48 m90 *1 654,2310
X_ex_48 VMID n_ex_I313 n_ex_I379 VDD n_ex_I445 VSS NANY
* cell instance $49 m90 *1 822,2310
X_ex_49 VMID n_ex_I443 tf_625b355d VDD n_ex_I313 VSS NANY
* cell instance $50 m90 *1 1038,66
X_ex_50 VDD n_ex_I214 n_ex_I244 VSS INV
* cell instance $51 r0 *1 1038,66
X_ex_51 VMID n_ex_I303 n_ex_I417 VDD n_ex_I384 VSS NANY
* cell instance $52 r0 *1 960,270
X_ex_52 VDD n_ex_I402 n_ex_I240 VSS INV
* cell instance $53 m90 *1 1176,270
X_ex_53 VDD n_ex_I384 n_ex_I241 VSS INV
* cell instance $54 r0 *1 900,474
X_ex_54 VMID n_ex_I255 n_ex_I449 VDD n_ex_I387 VSS NANY
* cell instance $55 r0 *1 1068,474
X_ex_55 VMID n_ex_I303 n_ex_I322 VDD n_ex_I388 VSS NANY
* cell instance $56 r0 *1 900,678
X_ex_56 VMID n_ex_I299 n_ex_I249 VDD tf_73756d5b325d VSS NANY
* cell instance $57 m90 *1 1236,678
X_ex_57 VMID n_ex_I299 n_ex_I428 VDD n_ex_I208 VSS NANY
* cell instance $58 r0 *1 900,882
X_ex_58 VMID n_ex_I417 n_ex_I433 VDD n_ex_I391 VSS NANY
* cell instance $59 r0 *1 1068,882
X_ex_59 VMID n_ex_I241 n_ex_I214 VDD n_ex_I392 VSS NANY
* cell instance $60 r0 *1 900,1086
X_ex_60 VMID n_ex_I417 n_ex_I327 VDD n_ex_I393 VSS NANY
* cell instance $61 r0 *1 1068,1086
X_ex_61 VMID n_ex_I322 n_ex_I234 VDD n_ex_I394 VSS NANY
* cell instance $62 m90 *1 1098,1290
X_ex_62 VMID n_ex_I255 n_ex_I408 VDD n_ex_I213 VSS NANY
* cell instance $63 r0 *1 1098,1290
X_ex_63 VDD n_ex_I387 n_ex_I229 VSS INV
* cell instance $64 r0 *1 960,1494
X_ex_64 VDD n_ex_I200 n_ex_I230 VSS INV
* cell instance $65 r0 *1 1068,1494
X_ex_65 VDD n_ex_I391 n_ex_I327 VSS INV
* cell instance $66 r0 *1 930,1698
X_ex_66 VDD n_ex_I203 n_ex_I374 VSS INV
* cell instance $67 m90 *1 1206,1698
X_ex_67 VMID n_ex_I445 n_ex_I230 VDD n_ex_I214 VSS NANY
* cell instance $68 m90 *1 1038,1902
X_ex_68 VDD tf_615b355d n_ex_I379 VSS INV
* cell instance $69 r0 *1 1038,1902
X_ex_69 VMID n_ex_I432 n_ex_I426 VDD n_ex_I196 VSS NANY
* cell instance $70 r0 *1 900,2106
X_ex_70 VMID n_ex_I243 n_ex_I195 VDD n_ex_I309 VSS NANY
* cell instance $71 r0 *1 1068,2106
X_ex_71 VMID n_ex_I441 n_ex_I225 VDD n_ex_I398 VSS NANY
* cell instance $72 r0 *1 900,2310
X_ex_72 VMID n_ex_I445 n_ex_I443 VDD n_ex_I200 VSS NANY
* cell instance $73 m90 *1 1236,2310
X_ex_73 VMID n_ex_I398 n_ex_I432 VDD n_ex_I203 VSS NANY
* cell instance $74 r0 *1 1314,66
X_ex_74 VMID n_ex_I408 n_ex_I329 VDD n_ex_I383 VSS NANY
* cell instance $75 r0 *1 1482,66
X_ex_75 VMID n_ex_I392 n_ex_I241 VDD n_ex_I390 VSS NANY
* cell instance $76 r0 *1 1344,270
X_ex_76 VDD n_ex_I388 n_ex_I369 VSS INV
* cell instance $77 m90 *1 1620,270
X_ex_77 VMID n_ex_I390 n_ex_I244 VDD n_ex_I423 VSS NANY
* cell instance $78 r0 *1 1344,474
X_ex_78 VMID n_ex_I428 n_ex_I240 VDD n_ex_I386 VSS NANY
* cell instance $79 r0 *1 1512,474
X_ex_79 VDD n_ex_I383 n_ex_I239 VSS INV
* cell instance $80 r0 *1 1344,678
X_ex_80 VMID n_ex_I425 n_ex_I239 VDD n_ex_I255 VSS NANY
* cell instance $81 r0 *1 1512,678
X_ex_81 VDD n_ex_I198 cout VSS INV
* cell instance $82 r0 *1 1344,882
X_ex_82 VDD n_ex_I410 n_ex_I329 VSS INV
* cell instance $83 r0 *1 1452,882
X_ex_83 VMID n_ex_I423 n_ex_I392 VDD n_ex_I415 VSS NANY
* cell instance $84 r0 *1 1344,1086
X_ex_84 VMID n_ex_I234 n_ex_I393 VDD n_ex_I322 VSS NANY
* cell instance $85 m90 *1 1620,1086
X_ex_85 VDD n_ex_I415 n_ex_I242 VSS INV
* cell instance $86 r0 *1 1344,1290
X_ex_86 VMID n_ex_I255 n_ex_I229 VDD tf_73756d5b305d VSS NANY
* cell instance $87 r0 *1 1512,1290
X_ex_87 VDD n_ex_I393 n_ex_I224 VSS INV
* cell instance $88 r0 *1 1314,1494
X_ex_88 VMID n_ex_I423 n_ex_I445 VDD n_ex_I198 VSS NANY
* cell instance $89 m90 *1 1650,1494
X_ex_89 VMID n_ex_I423 n_ex_I242 VDD tf_73756d5b355d VSS NANY
* cell instance $90 m90 *1 1482,1698
X_ex_90 VMID n_ex_I440 n_ex_I355 VDD n_ex_I299 VSS NANY
* cell instance $91 r0 *1 1482,1698
X_ex_91 VMID n_ex_I394 n_ex_I224 VDD n_ex_I303 VSS NANY
* cell instance $92 m90 *1 1452,1902
X_ex_92 VDD n_ex_I386 n_ex_I355 VSS INV
* cell instance $93 m90 *1 1620,1902
X_ex_93 VMID n_ex_I374 n_ex_I386 VDD n_ex_I365 VSS NANY
* cell instance $94 r0 *1 1374,2106
X_ex_94 VDD n_ex_I370 n_ex_I372 VSS INV
* cell instance $95 r0 *1 1482,2106
X_ex_95 VDD n_ex_I205 n_ex_I235 VSS INV
* cell instance $96 r0 *1 1314,2310
X_ex_96 VMID n_ex_I398 n_ex_I309 VDD n_ex_I205 VSS NANY
* cell instance $97 m90 *1 1650,2310
X_ex_97 VMID n_ex_I398 n_ex_I235 VDD tf_73756d5b315d VSS NANY
* Estimated lumped wire C to substrate (node 0); not signoff PEX
Ctfwire0 VDD 0 1.34887587812e-11
Ctfwire1 VMID 0 9.2341851776e-12
Ctfwire2 tf_615b355d 0 3.387013352e-13
Ctfwire3 tf_615b345d 0 2.463992536e-13
Ctfwire4 tf_615b335d 0 2.415188104e-13
Ctfwire5 tf_615b325d 0 2.73694512e-13
Ctfwire6 tf_615b315d 0 5.006517192e-13
Ctfwire7 tf_615b305d 0 2.121045152e-13
Ctfwire8 tf_625b355d 0 2.72467549e-13
Ctfwire9 tf_625b345d 0 2.64084987e-13
Ctfwire10 tf_625b335d 0 4.149825674e-13
Ctfwire11 tf_625b325d 0 2.37566547e-13
Ctfwire12 tf_625b315d 0 3.580886178e-13
Ctfwire13 tf_625b305d 0 3.585931818e-13
Ctfwire14 tf_73756d5b355d 0 2.01856091e-13
Ctfwire15 tf_73756d5b345d 0 1.664326694e-13
Ctfwire16 tf_73756d5b335d 0 3.80287091e-13
Ctfwire17 tf_73756d5b325d 0 1.122219526e-13
Ctfwire18 tf_73756d5b315d 0 2.353705678e-13
Ctfwire19 tf_73756d5b305d 0 8.7028955e-14
Ctfwire20 cin 0 6.806734374e-13
Ctfwire21 cout 0 6.62361414e-14
Ctfwire22 VSS 0 1.082108135e-11
Ctfwire23 n_ex_I449 0 2.047396436e-13
Ctfwire24 n_ex_I445 0 2.668960114e-13
Ctfwire25 n_ex_I443 0 2.42949222e-13
Ctfwire26 n_ex_I441 0 1.310796918e-13
Ctfwire27 n_ex_I440 0 1.677371974e-13
Ctfwire28 n_ex_I436 0 3.53271412e-13
Ctfwire29 n_ex_I433 0 3.07555512e-13
Ctfwire30 n_ex_I432 0 3.08839239e-13
Ctfwire31 n_ex_I429 0 1.649237414e-13
Ctfwire32 n_ex_I428 0 3.263203958e-13
Ctfwire33 n_ex_I427 0 7.81073824e-14
Ctfwire34 n_ex_I426 0 4.006407008e-13
Ctfwire35 n_ex_I425 0 1.844671934e-13
Ctfwire36 n_ex_I423 0 2.976112842e-13
Ctfwire37 n_ex_I417 0 5.03338003e-13
Ctfwire38 n_ex_I415 0 5.1111484e-14
Ctfwire39 n_ex_I414 0 7.43394824e-14
Ctfwire40 n_ex_I413 0 8.47591904e-14
Ctfwire41 n_ex_I412 0 2.356252942e-13
Ctfwire42 n_ex_I410 0 1.323541016e-13
Ctfwire43 n_ex_I409 0 6.7190419e-14
Ctfwire44 n_ex_I408 0 4.190683642e-13
Ctfwire45 n_ex_I405 0 1.813464336e-13
Ctfwire46 n_ex_I404 0 9.12458254e-14
Ctfwire47 n_ex_I402 0 2.164119592e-13
Ctfwire48 n_ex_I401 0 5.398618284e-13
Ctfwire49 n_ex_I398 0 1.587653206e-13
Ctfwire50 n_ex_I394 0 1.318258454e-13
Ctfwire51 n_ex_I393 0 1.275132178e-13
Ctfwire52 n_ex_I392 0 2.222852016e-13
Ctfwire53 n_ex_I391 0 1.423109328e-13
Ctfwire54 n_ex_I390 0 7.16891774e-14
Ctfwire55 n_ex_I388 0 7.02506384e-14
Ctfwire56 n_ex_I387 0 2.241713448e-13
Ctfwire57 n_ex_I386 0 2.590830046e-13
Ctfwire58 n_ex_I384 0 5.56102424e-14
Ctfwire59 n_ex_I383 0 2.253938162e-13
Ctfwire60 n_ex_I379 0 1.11668619e-13
Ctfwire61 n_ex_I374 0 1.735459024e-13
Ctfwire62 n_ex_I372 0 2.27311421e-13
Ctfwire63 n_ex_I370 0 3.445525662e-13
Ctfwire64 n_ex_I369 0 1.275990946e-13
Ctfwire65 n_ex_I368 0 2.974147414e-13
Ctfwire66 n_ex_I366 0 7.89066946e-14
Ctfwire67 n_ex_I365 0 2.385440696e-13
Ctfwire68 n_ex_I362 0 1.06083641e-13
Ctfwire69 n_ex_I361 0 1.799729052e-13
Ctfwire70 n_ex_I355 0 5.95645306e-14
Ctfwire71 n_ex_I329 0 1.394599434e-13
Ctfwire72 n_ex_I327 0 9.23910226e-14
Ctfwire73 n_ex_I322 0 2.155401296e-13
Ctfwire74 n_ex_I313 0 6.50142214e-14
Ctfwire75 n_ex_I309 0 2.100065856e-13
Ctfwire76 n_ex_I303 0 4.056852962e-13
Ctfwire77 n_ex_I302 0 2.902865814e-13
Ctfwire78 n_ex_I300 0 2.506138766e-13
Ctfwire79 n_ex_I299 0 4.615834446e-13
Ctfwire80 n_ex_I296 0 1.424538438e-13
Ctfwire81 n_ex_I295 0 2.794949618e-13
Ctfwire82 n_ex_I255 0 2.937795598e-13
Ctfwire83 n_ex_I251 0 1.61586867e-13
Ctfwire84 n_ex_I249 0 1.105290326e-13
Ctfwire85 n_ex_I248 0 3.229402258e-13
Ctfwire86 n_ex_I246 0 1.26991719e-13
Ctfwire87 n_ex_I244 0 1.336728686e-13
Ctfwire88 n_ex_I243 0 1.562357048e-13
Ctfwire89 n_ex_I242 0 9.7571367e-14
Ctfwire90 n_ex_I241 0 2.243636012e-13
Ctfwire91 n_ex_I240 0 9.2939379e-14
Ctfwire92 n_ex_I239 0 9.2815251e-14
Ctfwire93 n_ex_I238 0 2.010257888e-13
Ctfwire94 n_ex_I236 0 1.703830958e-13
Ctfwire95 n_ex_I235 0 7.1487039e-14
Ctfwire96 n_ex_I234 0 1.773167788e-13
Ctfwire97 n_ex_I230 0 8.0680899e-14
Ctfwire98 n_ex_I229 0 5.86787486e-14
Ctfwire99 n_ex_I226 0 1.05958059e-13
Ctfwire100 n_ex_I225 0 1.22871675e-13
Ctfwire101 n_ex_I224 0 1.17184935e-13
Ctfwire102 n_ex_I219 0 2.193433496e-13
Ctfwire103 n_ex_I214 0 2.370592286e-13
Ctfwire104 n_ex_I213 0 8.13530504e-14
Ctfwire105 n_ex_I208 0 1.572858464e-13
Ctfwire106 n_ex_I205 0 5.92180064e-14
Ctfwire107 n_ex_I203 0 1.487869736e-13
Ctfwire108 n_ex_I200 0 1.597445448e-13
Ctfwire109 n_ex_I198 0 1.385004952e-13
Ctfwire110 n_ex_I196 0 1.616460944e-13
Ctfwire111 n_ex_I195 0 1.536240418e-13
.ends adder6

* cell NANY
* pin VMID
* pin B
* pin A
* pin VDD
* pin Y
* pin VSS
.SUBCKT NANY VMID B A VDD Y VSS
* device instance $1 r0 *1 41,100 PMOS
XM_ex_1 n_ex_30 B n_ex_44 VDD PMOS L=1u W=34u AS=95.2p AD=95.2p PS=73.6u PD=73.6u
* device instance $2 r0 *1 26,100 PMOS
XM_ex_2 n_ex_44 A VDD VDD PMOS L=1u W=34u AS=95.2p AD=95.2p PS=73.6u PD=73.6u
* device instance $3 r0 *1 56,100 PMOS
XM_ex_3 n_ex_8 A Y VDD PMOS L=1u W=14u AS=39.2p AD=39.2p PS=33.6u PD=33.6u
* device instance $4 r0 *1 71,100 PMOS
XM_ex_4 n_ex_10 B Y VDD PMOS L=1u W=14u AS=39.2p AD=39.2p PS=33.6u PD=33.6u
* device instance $5 r0 *1 26,27 NMOS
XM_ex_5 n_ex_17 A n_ex_6 VSS NMOS L=1u W=11u AS=30.8p AD=30.8p PS=27.6u PD=27.6u
* device instance $6 r0 *1 41,27 NMOS
XM_ex_6 VSS B n_ex_17 VSS NMOS L=1u W=11u AS=30.8p AD=30.8p PS=27.6u PD=27.6u
* device instance $7 r0 *1 56,27 NMOS
XM_ex_7 n_ex_8 B VMID VSS NMOS L=1u W=8u AS=22.4p AD=22.4p PS=21.6u PD=21.6u
* device instance $8 r0 *1 71,27 NMOS
XM_ex_8 n_ex_10 A VMID VSS NMOS L=1u W=8u AS=22.4p AD=22.4p PS=21.6u PD=21.6u
* device instance $9 r0 *1 118.5,54 F_RR
XR_ex_9 n_ex_6 Y VDD F_RR R=10.7142857143 L=30u W=2.8u A=84p P=65.6u m=1
* device instance $10 r0 *1 118.5,84 F_RR
XR_ex_10 n_ex_30 Y VDD F_RR R=10.7142857143 L=30u W=2.8u A=84p P=65.6u m=1
.ENDS NANY

* cell INV
* pin VDD
* pin A
* pin Y
* pin VSS
.SUBCKT INV VDD A Y VSS
* device instance $1 r0 *1 19.2,56 PMOS
XM_ex_1 n_ex_5 A VDD VDD PMOS L=1u W=13.5u AS=37.8p AD=37.8p PS=32.6u PD=32.6u
* device instance $2 r0 *1 19.2,26 NMOS
XM_ex_2 n_ex_6 A VSS VSS NMOS L=1u W=5u AS=14p AD=14p PS=15.6u PD=15.6u
* device instance $3 r0 *1 70,44 F_RR
XR_ex_3 n_ex_6 Y VDD F_RR R=10.7142857143 L=30u W=2.8u A=84p P=65.6u m=1
* device instance $4 r0 *1 70,57 F_RR
XR_ex_4 n_ex_5 Y VDD F_RR R=10.7142857143 L=30u W=2.8u A=84p P=65.6u m=1
.ENDS INV

.temp 27
.options rshunt=1e12
VDD VDD 0 5
VMID VMID 0 0
VSS VSS 0 -5
Xdut VDD VMID tf_615b355d tf_615b345d tf_615b335d tf_615b325d tf_615b315d tf_615b305d tf_625b355d tf_625b345d tf_625b335d tf_625b325d tf_625b315d tf_625b305d tf_73756d5b355d tf_73756d5b345d tf_73756d5b335d tf_73756d5b325d tf_73756d5b315d tf_73756d5b305d cin cout VSS adder6
Vin0 tf_615b355d 0 DC 0 PWL(0 0 1e-06 0 1.001e-06 5 2e-06 5 2.001e-06 5 3e-06 5 3.001e-06 5 4e-06 5 4.001e-06 -5 5e-06 -5 5.001e-06 -5 6e-06 -5 6.001e-06 -5 7e-06 -5 7.001e-06 5 8e-06 5 8.001e-06 -5 9e-06 -5 9.001e-06 5 1e-05 5 1.0001e-05 -5)
Vin1 tf_615b345d 0 DC 0 PWL(0 0 1e-06 0 1.001e-06 5 2e-06 5 2.001e-06 5 3e-06 5 3.001e-06 5 4e-06 5 4.001e-06 -5 5e-06 -5 5.001e-06 -5 6e-06 -5 6.001e-06 -5 7e-06 -5 7.001e-06 5 8e-06 5 8.001e-06 -5 9e-06 -5 9.001e-06 5 1e-05 5 1.0001e-05 5)
Vin2 tf_615b335d 0 DC 0 PWL(0 0 1e-06 0 1.001e-06 5 2e-06 5 2.001e-06 5 3e-06 5 3.001e-06 5 4e-06 5 4.001e-06 -5 5e-06 -5 5.001e-06 -5 6e-06 -5 6.001e-06 -5 7e-06 -5 7.001e-06 5 8e-06 5 8.001e-06 -5 9e-06 -5 9.001e-06 5 1e-05 5 1.0001e-05 -5)
Vin3 tf_615b325d 0 DC 0 PWL(0 0 1e-06 0 1.001e-06 5 2e-06 5 2.001e-06 5 3e-06 5 3.001e-06 5 4e-06 5 4.001e-06 -5 5e-06 -5 5.001e-06 -5 6e-06 -5 6.001e-06 -5 7e-06 -5 7.001e-06 5 8e-06 5 8.001e-06 -5 9e-06 -5 9.001e-06 5 1e-05 5 1.0001e-05 5)
Vin4 tf_615b315d 0 DC 0 PWL(0 0 1e-06 0 1.001e-06 5 2e-06 5 2.001e-06 5 3e-06 5 3.001e-06 5 4e-06 5 4.001e-06 -5 5e-06 -5 5.001e-06 -5 6e-06 -5 6.001e-06 -5 7e-06 -5 7.001e-06 5 8e-06 5 8.001e-06 -5 9e-06 -5 9.001e-06 5 1e-05 5 1.0001e-05 -5)
Vin5 tf_615b305d 0 DC 0 PWL(0 0 1e-06 0 1.001e-06 5 2e-06 5 2.001e-06 5 3e-06 5 3.001e-06 5 4e-06 5 4.001e-06 -5 5e-06 -5 5.001e-06 -5 6e-06 -5 6.001e-06 -5 7e-06 -5 7.001e-06 5 8e-06 5 8.001e-06 -5 9e-06 -5 9.001e-06 5 1e-05 5 1.0001e-05 5)
Vin6 tf_625b355d 0 DC 0 PWL(0 0 1e-06 0 1.001e-06 0 2e-06 0 2.001e-06 0 3e-06 0 3.001e-06 0 4e-06 0 4.001e-06 0 5e-06 0 5.001e-06 0 6e-06 0 6.001e-06 0 7e-06 0 7.001e-06 5 8e-06 5 8.001e-06 -5 9e-06 -5 9.001e-06 -5 1e-05 -5 1.0001e-05 5)
Vin7 tf_625b345d 0 DC 0 PWL(0 0 1e-06 0 1.001e-06 0 2e-06 0 2.001e-06 0 3e-06 0 3.001e-06 0 4e-06 0 4.001e-06 0 5e-06 0 5.001e-06 0 6e-06 0 6.001e-06 0 7e-06 0 7.001e-06 5 8e-06 5 8.001e-06 -5 9e-06 -5 9.001e-06 -5 1e-05 -5 1.0001e-05 -5)
Vin8 tf_625b335d 0 DC 0 PWL(0 0 1e-06 0 1.001e-06 0 2e-06 0 2.001e-06 0 3e-06 0 3.001e-06 0 4e-06 0 4.001e-06 0 5e-06 0 5.001e-06 0 6e-06 0 6.001e-06 0 7e-06 0 7.001e-06 5 8e-06 5 8.001e-06 -5 9e-06 -5 9.001e-06 -5 1e-05 -5 1.0001e-05 5)
Vin9 tf_625b325d 0 DC 0 PWL(0 0 1e-06 0 1.001e-06 0 2e-06 0 2.001e-06 0 3e-06 0 3.001e-06 0 4e-06 0 4.001e-06 0 5e-06 0 5.001e-06 0 6e-06 0 6.001e-06 0 7e-06 0 7.001e-06 5 8e-06 5 8.001e-06 -5 9e-06 -5 9.001e-06 -5 1e-05 -5 1.0001e-05 -5)
Vin10 tf_625b315d 0 DC 0 PWL(0 0 1e-06 0 1.001e-06 0 2e-06 0 2.001e-06 0 3e-06 0 3.001e-06 0 4e-06 0 4.001e-06 0 5e-06 0 5.001e-06 0 6e-06 0 6.001e-06 0 7e-06 0 7.001e-06 5 8e-06 5 8.001e-06 -5 9e-06 -5 9.001e-06 -5 1e-05 -5 1.0001e-05 5)
Vin11 tf_625b305d 0 DC 0 PWL(0 0 1e-06 0 1.001e-06 0 2e-06 0 2.001e-06 0 3e-06 0 3.001e-06 0 4e-06 0 4.001e-06 0 5e-06 0 5.001e-06 0 6e-06 0 6.001e-06 0 7e-06 0 7.001e-06 5 8e-06 5 8.001e-06 -5 9e-06 -5 9.001e-06 -5 1e-05 -5 1.0001e-05 -5)
Vin12 cin 0 DC 0 PWL(0 0 1e-06 0 1.001e-06 0 2e-06 0 2.001e-06 5 3e-06 5 3.001e-06 0 4e-06 0 4.001e-06 0 5e-06 0 5.001e-06 -5 6e-06 -5 6.001e-06 0 7e-06 0 7.001e-06 5 8e-06 5 8.001e-06 -5 9e-06 -5 9.001e-06 0 1e-05 0 1.0001e-05 5)
Cload0 tf_73756d5b355d 0 1e-14
Cload1 tf_73756d5b345d 0 1e-14
Cload2 tf_73756d5b335d 0 1e-14
Cload3 tf_73756d5b325d 0 1e-14
Cload4 tf_73756d5b315d 0 1e-14
Cload5 tf_73756d5b305d 0 1e-14
Cload6 cout 0 1e-14
.nodeset v(tf_73756d5b355d)=0
.nodeset v(tf_73756d5b345d)=0
.nodeset v(tf_73756d5b335d)=0
.nodeset v(tf_73756d5b325d)=0
.nodeset v(tf_73756d5b315d)=0
.nodeset v(tf_73756d5b305d)=0
.nodeset v(cout)=0
.nodeset v(xdut.n_ex_I443)=0
.nodeset v(xdut.n_ex_I379)=0
.nodeset v(xdut.n_ex_I246)=0
.nodeset v(xdut.n_ex_I433)=0
.nodeset v(xdut.n_ex_I236)=0
.nodeset v(xdut.n_ex_I361)=0
.nodeset v(xdut.n_ex_I362)=0
.nodeset v(xdut.n_ex_I401)=0
.nodeset v(xdut.n_ex_I366)=0
.nodeset v(xdut.n_ex_I426)=0
.nodeset v(xdut.n_ex_I251)=0
.nodeset v(xdut.n_ex_I405)=0
.nodeset v(xdut.n_ex_I313)=0
.nodeset v(xdut.n_ex_I412)=0
.nodeset v(xdut.n_ex_I429)=0
.nodeset v(xdut.n_ex_I296)=0
.nodeset v(xdut.n_ex_I300)=0
.nodeset v(xdut.n_ex_I404)=0
.nodeset v(xdut.n_ex_I445)=0
.nodeset v(xdut.n_ex_I417)=0
.nodeset v(xdut.n_ex_I295)=0
.nodeset v(xdut.n_ex_I428)=0
.nodeset v(xdut.n_ex_I432)=0
.nodeset v(xdut.n_ex_I408)=0
.nodeset v(xdut.n_ex_I200)=0
.nodeset v(xdut.n_ex_I391)=0
.nodeset v(xdut.n_ex_I427)=0
.nodeset v(xdut.n_ex_I402)=0
.nodeset v(xdut.n_ex_I196)=0
.nodeset v(xdut.n_ex_I410)=0
.nodeset v(xdut.n_ex_I230)=0
.nodeset v(xdut.n_ex_I327)=0
.nodeset v(xdut.n_ex_I248)=0
.nodeset v(xdut.n_ex_I240)=0
.nodeset v(xdut.n_ex_I226)=0
.nodeset v(xdut.n_ex_I329)=0
.nodeset v(xdut.n_ex_I214)=0
.nodeset v(xdut.n_ex_I393)=0
.nodeset v(xdut.n_ex_I370)=0
.nodeset v(xdut.n_ex_I386)=0
.nodeset v(xdut.n_ex_I195)=0
.nodeset v(xdut.n_ex_I383)=0
.nodeset v(xdut.n_ex_I244)=0
.nodeset v(xdut.n_ex_I224)=0
.nodeset v(xdut.n_ex_I372)=0
.nodeset v(xdut.n_ex_I355)=0
.nodeset v(xdut.n_ex_I225)=0
.nodeset v(xdut.n_ex_I239)=0
.nodeset v(xdut.n_ex_I449)=0
.nodeset v(xdut.n_ex_I425)=0
.nodeset v(xdut.n_ex_I255)=0
.nodeset v(xdut.n_ex_I213)=0
.nodeset v(xdut.n_ex_I387)=0
.nodeset v(xdut.n_ex_I243)=0
.nodeset v(xdut.n_ex_I229)=0
.nodeset v(xdut.n_ex_I309)=0
.nodeset v(xdut.n_ex_I441)=0
.nodeset v(xdut.n_ex_I398)=0
.nodeset v(xdut.n_ex_I203)=0
.nodeset v(xdut.n_ex_I205)=0
.nodeset v(xdut.n_ex_I374)=0
.nodeset v(xdut.n_ex_I235)=0
.nodeset v(xdut.n_ex_I365)=0
.nodeset v(xdut.n_ex_I440)=0
.nodeset v(xdut.n_ex_I299)=0
.nodeset v(xdut.n_ex_I208)=0
.nodeset v(xdut.n_ex_I219)=0
.nodeset v(xdut.n_ex_I238)=0
.nodeset v(xdut.n_ex_I249)=0
.nodeset v(xdut.n_ex_I436)=0
.nodeset v(xdut.n_ex_I409)=0
.nodeset v(xdut.n_ex_I302)=0
.nodeset v(xdut.n_ex_I413)=0
.nodeset v(xdut.n_ex_I414)=0
.nodeset v(xdut.n_ex_I234)=0
.nodeset v(xdut.n_ex_I368)=0
.nodeset v(xdut.n_ex_I322)=0
.nodeset v(xdut.n_ex_I394)=0
.nodeset v(xdut.n_ex_I303)=0
.nodeset v(xdut.n_ex_I384)=0
.nodeset v(xdut.n_ex_I388)=0
.nodeset v(xdut.n_ex_I241)=0
.nodeset v(xdut.n_ex_I369)=0
.nodeset v(xdut.n_ex_I392)=0
.nodeset v(xdut.n_ex_I390)=0
.nodeset v(xdut.n_ex_I423)=0
.nodeset v(xdut.n_ex_I415)=0
.nodeset v(xdut.n_ex_I198)=0
.nodeset v(xdut.n_ex_I242)=0

.control
set noaskquit
set wr_singlescale
set wr_vecnames
set numdgt=15
tran 2e-09 1.1e-05 0 2e-09
wrdata waveform.txt v(xdut.n_ex_I443) v(xdut.n_ex_I379) v(xdut.n_ex_I417) v(xdut.n_ex_I391) v(xdut.n_ex_I327) v(xdut.n_ex_I393) v(xdut.n_ex_I224) v(xdut.n_ex_I236) v(xdut.n_ex_I361) v(xdut.n_ex_I429) v(xdut.n_ex_I295) v(xdut.n_ex_I427) v(xdut.n_ex_I313) v(xdut.n_ex_I248) v(xdut.n_ex_I370) v(xdut.n_ex_I372) v(xdut.n_ex_I362) v(xdut.n_ex_I401) v(xdut.n_ex_I296) v(xdut.n_ex_I428) v(xdut.n_ex_I402) v(xdut.n_ex_I240) v(xdut.n_ex_I386) v(xdut.n_ex_I445) v(xdut.n_ex_I355) v(xdut.n_ex_I366) v(xdut.n_ex_I426) v(xdut.n_ex_I300) v(xdut.n_ex_I432) v(xdut.n_ex_I196) v(xdut.n_ex_I226) v(xdut.n_ex_I195) v(xdut.n_ex_I225) v(xdut.n_ex_I251) v(xdut.n_ex_I200) v(xdut.n_ex_I405) v(xdut.n_ex_I404) v(xdut.n_ex_I408) v(xdut.n_ex_I410) v(xdut.n_ex_I329) v(xdut.n_ex_I383) v(xdut.n_ex_I239) v(xdut.n_ex_I449) v(xdut.n_ex_I425) v(xdut.n_ex_I255) v(xdut.n_ex_I230) v(xdut.n_ex_I213) v(xdut.n_ex_I243) v(xdut.n_ex_I309) v(xdut.n_ex_I441) v(xdut.n_ex_I398) v(xdut.n_ex_I203) v(xdut.n_ex_I374) v(xdut.n_ex_I365) v(xdut.n_ex_I440) v(xdut.n_ex_I299) v(xdut.n_ex_I214) v(xdut.n_ex_I208) v(xdut.n_ex_I238) v(xdut.n_ex_I436) v(xdut.n_ex_I409) v(xdut.n_ex_I302) v(xdut.n_ex_I413) v(xdut.n_ex_I234) v(xdut.n_ex_I322) v(xdut.n_ex_I394) v(xdut.n_ex_I303) v(xdut.n_ex_I246) v(xdut.n_ex_I384) v(xdut.n_ex_I241) v(xdut.n_ex_I392) v(xdut.n_ex_I244) v(xdut.n_ex_I390) v(xdut.n_ex_I423) v(xdut.n_ex_I415) v(xdut.n_ex_I242) v(xdut.n_ex_I388) v(xdut.n_ex_I433) v(xdut.n_ex_I369) v(xdut.n_ex_I414) v(xdut.n_ex_I368) v(xdut.n_ex_I219) v(xdut.n_ex_I249) v(xdut.n_ex_I205) v(xdut.n_ex_I235) v(xdut.n_ex_I412) v(xdut.n_ex_I387) v(xdut.n_ex_I229) v(xdut.n_ex_I198) v(tf_615b305d) v(tf_615b315d) v(tf_615b325d) v(tf_615b335d) v(tf_615b345d) v(tf_615b355d) v(tf_625b305d) v(tf_625b315d) v(tf_625b325d) v(tf_625b335d) v(tf_625b345d) v(tf_625b355d) v(cin) v(cout) v(tf_73756d5b305d) v(tf_73756d5b315d) v(tf_73756d5b325d) v(tf_73756d5b335d) v(tf_73756d5b345d) v(tf_73756d5b355d)
quit
.endc
.end
