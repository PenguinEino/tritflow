* TritFlow cell netlist: trits -1/0/+1 at -5/0/+5 V.
* net tf_795b305d = y[0]
* net tf_795b315d = y[1]
.subckt dot4 w0 w1 w2 w3 x0 x1 x2 x3 tf_795b315d tf_795b305d VDD VMID VSS
Xg0 w0 x0 _n0 VDD VMID VSS NAND
Xg1 w0 x0 _n1 VDD VMID VSS NOR
Xg5 w1 x1 _n5 VDD VMID VSS NAND
Xg6 w1 x1 _n6 VDD VMID VSS NOR
Xg16 w2 x2 _n16 VDD VMID VSS NAND
Xg17 w2 x2 _n17 VDD VMID VSS NOR
Xg27 w3 x3 _n27 VDD VMID VSS NAND
Xg28 w3 x3 _n28 VDD VMID VSS NOR
Xg2 _n1 _n2 VDD VMID VSS INV
Xg7 _n6 _n7 VDD VMID VSS INV
Xg18 _n17 _n18 VDD VMID VSS INV
Xg29 _n28 _n29 VDD VMID VSS INV
Xg3 _n0 _n2 _n3 VDD VMID VSS NAND
Xg8 _n5 _n7 _n8 VDD VMID VSS NAND
Xg19 _n16 _n18 _n19 VDD VMID VSS NAND
Xg30 _n27 _n29 _n30 VDD VMID VSS NAND
Xg4 _n3 _n4 VDD VMID VSS INV
Xg9 _n3 _n8 _n9 VDD VMID VSS NANY
Xg10 _n8 _n9 _n10 VDD VMID VSS NANY
Xg11 _n4 _n10 _n11 VDD VMID VSS NANY
Xg12 _n9 _n11 _n12 VDD VMID VSS NANY
Xg37 _n11 _n37 VDD VMID VSS INV
Xg13 _n12 _n13 VDD VMID VSS INV
Xg14 _n13 _n11 _n14 VDD VMID VSS NANY
Xg15 _n14 _n15 VDD VMID VSS INV
Xg20 _n14 _n19 _n20 VDD VMID VSS NANY
Xg21 _n19 _n20 _n21 VDD VMID VSS NANY
Xg22 _n15 _n21 _n22 VDD VMID VSS NANY
Xg23 _n20 _n22 _n23 VDD VMID VSS NANY
Xg24 _n23 _n24 VDD VMID VSS INV
Xg25 _n24 _n22 _n25 VDD VMID VSS NANY
Xg26 _n25 _n26 VDD VMID VSS INV
Xg31 _n25 _n30 _n31 VDD VMID VSS NANY
Xg32 _n30 _n31 _n32 VDD VMID VSS NANY
Xg33 _n26 _n32 _n33 VDD VMID VSS NANY
Xg34 _n22 _n33 _n34 VDD VMID VSS NANY
Xg43 _n31 _n33 _n43 VDD VMID VSS NANY
Xg35 _n34 _n35 VDD VMID VSS INV
Xg44 _n43 _n44 VDD VMID VSS INV
Xg36 _n11 _n35 _n36 VDD VMID VSS NANY
Xg45 _n44 _n33 tf_795b305d VDD VMID VSS NANY
Xg38 _n35 _n36 _n38 VDD VMID VSS NANY
Xg39 _n37 _n38 _n39 VDD VMID VSS NANY
Xg40 _n36 _n39 _n40 VDD VMID VSS NANY
Xg41 _n40 _n41 VDD VMID VSS INV
Xg42 _n41 _n39 tf_795b315d VDD VMID VSS NANY
.ends dot4

* RR30 schematic connectivity; lengths in micrometres
.subckt INV A Y VDD VMID VSS
XMP p A VDD VDD PMOS W=13.5u L=1u
XMN n A VSS VSS NMOS W=5u L=1u
XRP p Y VDD F_RR W=2.8u L=30u
XRN Y n VDD F_RR W=2.8u L=30u
.ends INV
* RR30 schematic connectivity; lengths in micrometres
.subckt NAND A B Y VDD VMID VSS
XP1 p A VDD VDD PMOS W=19u L=1u
XP2 p B VDD VDD PMOS W=19u L=1u
XN1 n A nn VSS NMOS W=13u L=1u
XN2 nn B VSS VSS NMOS W=13u L=1u
XRP p Y VDD F_RR W=2.8u L=30u
XRN Y n VDD F_RR W=2.8u L=30u
.ends NAND
* RR30 schematic connectivity; lengths in micrometres
.subckt NOR A B Y VDD VMID VSS
XP1 pp A VDD VDD PMOS W=37u L=1u
XP2 p B pp VDD PMOS W=37u L=1u
XN1 n A VSS VSS NMOS W=6.5u L=1u
XN2 n B VSS VSS NMOS W=6.5u L=1u
XRP p Y VDD F_RR W=2.8u L=30u
XRN Y n VDD F_RR W=2.8u L=30u
.ends NOR
* RR30 schematic connectivity; lengths in micrometres
.subckt NANY A B Y VDD VMID VSS
XP1 pp A VDD VDD PMOS W=34u L=1u
XP2 p B pp VDD PMOS W=34u L=1u
XN1 n A nn VSS NMOS W=11u L=1u
XN2 nn B VSS VSS NMOS W=11u L=1u
XCP1 c1 A Y VDD PMOS W=14u L=1u
XCN1 c1 B VMID VSS NMOS W=8u L=1u
XCP2 c2 B Y VDD PMOS W=14u L=1u
XCN2 c2 A VMID VSS NMOS W=8u L=1u
XRP p Y VDD F_RR W=2.8u L=30u
XRN Y n VDD F_RR W=2.8u L=30u
.ends NANY
* RR30 schematic connectivity; lengths in micrometres
.subckt BUF A Y VDD VMID VSS
XMP0 p0 A VDD VDD PMOS W=13.5u L=1u
XMN0 n0 A VSS VSS NMOS W=5u L=1u
XMP1 p1 mid VDD VDD PMOS W=13.5u L=1u
XMN1 n1 mid VSS VSS NMOS W=5u L=1u
XRP0 p0 mid VDD F_RR W=2.8u L=30u
XRN0 mid n0 VDD F_RR W=2.8u L=30u
XRP1 p1 Y VDD F_RR W=2.8u L=30u
XRN1 Y n1 VDD F_RR W=2.8u L=30u
.ends BUF
* RR30 schematic connectivity; lengths in micrometres
.subckt TIEP Y VDD VMID VSS
XRT Y VDD VDD F_RR W=2.8u L=30u
.ends TIEP
* RR30 schematic connectivity; lengths in micrometres
.subckt TIEZ Y VDD VMID VSS
XRT Y VMID VDD F_RR W=2.8u L=30u
.ends TIEZ
* RR30 schematic connectivity; lengths in micrometres
.subckt TIEN Y VDD VMID VSS
XRT Y VSS VDD F_RR W=2.8u L=30u
.ends TIEN
* RR30 schematic connectivity; lengths in micrometres
.subckt FILL VDD VMID VSS
.ends FILL

.subckt tr_1um_dot4 w0 w1 w2 w3 x0 x1 x2 x3 tf_795b315d tf_795b305d VDD VMID VSS
Xmacro w0 w1 w2 w3 x0 x1 x2 x3 tf_795b315d tf_795b305d VDD VMID VSS dot4
.ends tr_1um_dot4
