** sch_path: /home/ishi-kai/balanced-ternary-logic/inverter.sch
.subckt inverter vin vout VDD VSS
*.PININFO VDD:B vin:I vout:O VSS:B
MXM1 net1 vin VDD VDD PMOS w=13.5u l=1u
XR1 net1 vout VDD F_RR w=2.8e-06 l=30e-06
XR2 vout net2 VDD F_RR w=2.8e-06 l=30e-06
MXM2 net2 vin VSS VSS NMOS w=5u l=1u
.ends
