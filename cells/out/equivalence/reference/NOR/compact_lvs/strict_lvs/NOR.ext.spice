* Created by KLayout
*** My special header ***

* cell NOR
* pin A
* pin B
* pin VDD
* pin VSS
* pin Y
.SUBCKT NOR A B VDD VSS Y VMID
* device instance $1 r0 *1 26,100 PMOS
XM$1 \$18 A VDD VDD PMOS L=1u W=37u AS=103.6p AD=103.6p PS=79.6u PD=79.6u
* device instance $2 r0 *1 41,100 PMOS
XM$2 \$4 B \$18 VDD PMOS L=1u W=37u AS=103.6p AD=103.6p PS=79.6u PD=79.6u
* device instance $3 r0 *1 26,28 NMOS
XM$3 \$5 A VSS VSS NMOS L=1u W=6.5u AS=18.2p AD=18.2p PS=18.6u PD=18.6u
* device instance $4 r0 *1 41,28 NMOS
XM$4 \$5 B VSS VSS NMOS L=1u W=6.5u AS=18.2p AD=18.2p PS=18.6u PD=18.6u
* device instance $5 r0 *1 96,54 F_RR
XR$5 \$5 Y VDD F_RR R=10.7142857143 L=30u W=2.8u A=84p P=65.6u m=1
* device instance $6 r0 *1 96,84 F_RR
XR$6 \$4 Y VDD F_RR R=10.7142857143 L=30u W=2.8u A=84p P=65.6u m=1
.ENDS NOR
