TritFlow ternary testbench
*
.parameters vthMP	= 0
.parameters vthMN 	= 0
.parameters vthMPE      = 0
.parameters vthMNE      = 0
.parameters magRR       = 1
.parameters magRS       = 1
.parameters magCSIO     = 1
.include "/home/ishi-kai/pdk/TR-1um-pinned/libs.tech/spice/models/models_IP62_cap_v5p1.lib"
.include "/home/ishi-kai/pdk/TR-1um-pinned/libs.tech/spice/models/models_IP62_diode_v2.lib"
.include "/home/ishi-kai/pdk/TR-1um-pinned/libs.tech/spice/models/models_IP62_mos_v2.lib"
.include "/home/ishi-kai/pdk/TR-1um-pinned/libs.tech/spice/models/models_IP62_res_v5.lib"
* Public ports renamed from independent taped-out reference
.subckt NAND A B Y VDD VMID VSS
* device instance $1 r0 *1 20,96 PMOS
XM_ex_1 n_ex_3 A VDD VDD PMOS L=1u W=19u AS=53.2p AD=53.2p PS=43.6u PD=43.6u
* device instance $2 r0 *1 35,96 PMOS
XM_ex_2 n_ex_3 B VDD VDD PMOS L=1u W=19u AS=53.2p AD=53.2p PS=43.6u PD=43.6u
* device instance $3 r0 *1 20,16 NMOS
XM_ex_3 n_ex_16 A n_ex_5 VSS NMOS L=1u W=13u AS=36.4p AD=36.4p PS=31.6u PD=31.6u
* device instance $4 r0 *1 35,16 NMOS
XM_ex_4 VSS B n_ex_16 VSS NMOS L=1u W=13u AS=36.4p AD=36.4p PS=31.6u PD=31.6u
* device instance $5 r0 *1 90,42 F_RR
XR_ex_5 n_ex_5 Y VDD F_RR R=10.7142857143 L=30u W=2.8u A=84p P=65.6u m=1
* device instance $6 r0 *1 90,78 F_RR
XR_ex_6 n_ex_3 Y VDD F_RR R=10.7142857143 L=30u W=2.8u A=84p P=65.6u m=1
.ends NAND

.temp 27
.options rshunt=1e12
VDD VDD 0 5
VMID VMID 0 0
VSS VSS 0 -5
Xdut A B Y VDD VMID VSS NAND
Vin0 A 0 PWL(0 -5 1e-07 -5 1.01e-07 5 2e-07 5 2.01e-07 5 3e-07 5 3.01e-07 5 4e-07 5 4.01e-07 5 5e-07 5 5.01e-07 5 6e-07 5 6.01e-07 0 7e-07 0 7.01e-07 5 8e-07 5 8.01e-07 0 9e-07 0 9.01e-07 5 1e-06 5 1.001e-06 0 1.1e-06 0 1.101e-06 5 1.2e-06 5 1.201e-06 -5 1.3e-06 -5 1.301e-06 5 1.4e-06 5 1.401e-06 -5 1.5e-06 -5 1.501e-06 5 1.6e-06 5 1.601e-06 -5 1.7e-06 -5 1.701e-06 5 1.8e-06 5 1.801e-06 5 1.9e-06 5 1.901e-06 5 2e-06 5 2.001e-06 0 2.1e-06 0 2.101e-06 5 2.2e-06 5 2.201e-06 0 2.3e-06 0 2.301e-06 5 2.4e-06 5 2.401e-06 0 2.5e-06 0 2.501e-06 5 2.6e-06 5 2.601e-06 -5 2.7e-06 -5 2.701e-06 5 2.8e-06 5 2.801e-06 -5 2.9e-06 -5 2.901e-06 5 3e-06 5 3.001e-06 -5 3.1e-06 -5 3.101e-06 5 3.2e-06 5 3.201e-06 0 3.3e-06 0 3.301e-06 5 3.4e-06 5 3.401e-06 0 3.5e-06 0 3.501e-06 5 3.6e-06 5 3.601e-06 0 3.7e-06 0 3.701e-06 5 3.8e-06 5 3.801e-06 -5 3.9e-06 -5 3.901e-06 5 4e-06 5 4.001e-06 -5 4.1e-06 -5 4.101e-06 5 4.2e-06 5 4.201e-06 -5 4.3e-06 -5 4.301e-06 0 4.4e-06 0 4.401e-06 0 4.5e-06 0 4.501e-06 0 4.6e-06 0 4.601e-06 0 4.7e-06 0 4.701e-06 0 4.8e-06 0 4.801e-06 -5 4.9e-06 -5 4.901e-06 0 5e-06 0 5.001e-06 -5 5.1e-06 -5 5.101e-06 0 5.2e-06 0 5.201e-06 -5 5.3e-06 -5 5.301e-06 0 5.4e-06 0 5.401e-06 0 5.5e-06 0 5.501e-06 0 5.6e-06 0 5.601e-06 -5 5.7e-06 -5 5.701e-06 0 5.8e-06 0 5.801e-06 -5 5.9e-06 -5 5.901e-06 0 6e-06 0 6.001e-06 -5 6.1e-06 -5 6.101e-06 0 6.2e-06 0 6.201e-06 -5 6.3e-06 -5 6.301e-06 0 6.4e-06 0 6.401e-06 -5 6.5e-06 -5 6.501e-06 0 6.6e-06 0 6.601e-06 -5 6.7e-06 -5 6.701e-06 -5 6.8e-06 -5 6.801e-06 -5 6.9e-06 -5 6.901e-06 -5 7e-06 -5 7.001e-06 -5 7.1e-06 -5 7.101e-06 -5 7.2e-06 -5 7.201e-06 -5)
Vin1 B 0 PWL(0 -5 1e-07 -5 1.01e-07 5 2e-07 5 2.01e-07 0 3e-07 0 3.01e-07 5 4e-07 5 4.01e-07 -5 5e-07 -5 5.01e-07 5 6e-07 5 6.01e-07 5 7e-07 5 7.01e-07 5 8e-07 5 8.01e-07 0 9e-07 0 9.01e-07 5 1e-06 5 1.001e-06 -5 1.1e-06 -5 1.101e-06 5 1.2e-06 5 1.201e-06 5 1.3e-06 5 1.301e-06 5 1.4e-06 5 1.401e-06 0 1.5e-06 0 1.501e-06 5 1.6e-06 5 1.601e-06 -5 1.7e-06 -5 1.701e-06 0 1.8e-06 0 1.801e-06 -5 1.9e-06 -5 1.901e-06 0 2e-06 0 2.001e-06 5 2.1e-06 5 2.101e-06 0 2.2e-06 0 2.201e-06 0 2.3e-06 0 2.301e-06 0 2.4e-06 0 2.401e-06 -5 2.5e-06 -5 2.501e-06 0 2.6e-06 0 2.601e-06 5 2.7e-06 5 2.701e-06 0 2.8e-06 0 2.801e-06 0 2.9e-06 0 2.901e-06 0 3e-06 0 3.001e-06 -5 3.1e-06 -5 3.101e-06 -5 3.2e-06 -5 3.201e-06 5 3.3e-06 5 3.301e-06 -5 3.4e-06 -5 3.401e-06 0 3.5e-06 0 3.501e-06 -5 3.6e-06 -5 3.601e-06 -5 3.7e-06 -5 3.701e-06 -5 3.8e-06 -5 3.801e-06 5 3.9e-06 5 3.901e-06 -5 4e-06 -5 4.001e-06 0 4.1e-06 0 4.101e-06 -5 4.2e-06 -5 4.201e-06 -5 4.3e-06 -5 4.301e-06 5 4.4e-06 5 4.401e-06 0 4.5e-06 0 4.501e-06 5 4.6e-06 5 4.601e-06 -5 4.7e-06 -5 4.701e-06 5 4.8e-06 5 4.801e-06 5 4.9e-06 5 4.901e-06 5 5e-06 5 5.001e-06 0 5.1e-06 0 5.101e-06 5 5.2e-06 5 5.201e-06 -5 5.3e-06 -5 5.301e-06 0 5.4e-06 0 5.401e-06 -5 5.5e-06 -5 5.501e-06 0 5.6e-06 0 5.601e-06 5 5.7e-06 5 5.701e-06 0 5.8e-06 0 5.801e-06 0 5.9e-06 0 5.901e-06 0 6e-06 0 6.001e-06 -5 6.1e-06 -5 6.101e-06 -5 6.2e-06 -5 6.201e-06 5 6.3e-06 5 6.301e-06 -5 6.4e-06 -5 6.401e-06 0 6.5e-06 0 6.501e-06 -5 6.6e-06 -5 6.601e-06 -5 6.7e-06 -5 6.701e-06 5 6.8e-06 5 6.801e-06 0 6.9e-06 0 6.901e-06 5 7e-06 5 7.001e-06 -5 7.1e-06 -5 7.101e-06 0 7.2e-06 0 7.201e-06 -5)
Cload0 Y 0 1e-14
.nodeset v(Y)=5
.nodeset v(xdut.n_ex_3)=5
.nodeset v(xdut.n_ex_16)=-5
.nodeset v(xdut.n_ex_5)=-5
.control
set noaskquit
set wr_singlescale
set wr_vecnames
set numdgt=15
tran 1e-10 7.3e-06 0 1e-10
wrdata waveform.txt v(A) v(B) v(Y) i(vdd) i(vmid) i(vss)
quit
.endc
.end
