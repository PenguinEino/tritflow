* Public ports renamed from independent taped-out reference
.subckt NAND A B Y VDD VMID VSS
* device instance $1 r0 *1 20,96 PMOS
XM$1 \$3 A VDD VDD PMOS L=1u W=19u AS=53.2p AD=53.2p PS=43.6u PD=43.6u
* device instance $2 r0 *1 35,96 PMOS
XM$2 \$3 B VDD VDD PMOS L=1u W=19u AS=53.2p AD=53.2p PS=43.6u PD=43.6u
* device instance $3 r0 *1 20,16 NMOS
XM$3 \$16 A \$5 VSS NMOS L=1u W=13u AS=36.4p AD=36.4p PS=31.6u PD=31.6u
* device instance $4 r0 *1 35,16 NMOS
XM$4 VSS B \$16 VSS NMOS L=1u W=13u AS=36.4p AD=36.4p PS=31.6u PD=31.6u
* device instance $5 r0 *1 90,42 F_RR
XR$5 \$5 Y VDD F_RR R=10.7142857143 L=30u W=2.8u A=84p P=65.6u m=1
* device instance $6 r0 *1 90,78 F_RR
XR$6 \$3 Y VDD F_RR R=10.7142857143 L=30u W=2.8u A=84p P=65.6u m=1
* Estimated lumped wire C to substrate (node 0); not signoff PEX
Ctfwire0 VDD 0 5.3510866e-14
Ctfwire1 \$3 0 2.3431911e-14
Ctfwire2 \$5 0 1.32774498e-14
Ctfwire3 A 0 3.651473e-15
Ctfwire4 B 0 5.132243e-15
Ctfwire5 Y 0 8.5148656e-15
Ctfwire6 \$16 0 4.4645408e-15
Ctfwire7 VSS 0 2.6662408e-14
.ends NAND
