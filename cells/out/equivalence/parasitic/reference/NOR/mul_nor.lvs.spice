** sch_path: /home/ishi-kai/balanced-ternary-logic/mul_nor.sch
.subckt mul_nor a b vout V+ V-
*.PININFO V+:B a:I b:I vout:O V-:B
MXM4 net1 a V+ V+ PMOS w=37u l=1u
MXM3 net2 b net1 V+ PMOS w=37u l=1u
XR2 net2 vout V+ F_RR w=2.8e-06 l=30e-06
XR1 vout net3 V+ F_RR w=2.8e-06 l=30e-06
MXM2 net3 a V- V- NMOS w=6.5u l=1u
MXM1 net3 b V- V- NMOS w=6.5u l=1u
.ends
