* Public ports renamed from independent taped-out reference
.subckt NOR A B Y VDD VMID VSS
* device instance $1 r0 *1 20,96 PMOS
XM$1 \$16 A VDD VDD PMOS L=1u W=37u AS=103.6p AD=103.6p PS=79.6u PD=79.6u
* device instance $2 r0 *1 35,96 PMOS
XM$2 \$3 B \$16 VDD PMOS L=1u W=37u AS=103.6p AD=103.6p PS=79.6u PD=79.6u
* device instance $3 r0 *1 20,16 NMOS
XM$3 \$4 A VSS VSS NMOS L=1u W=6.5u AS=18.2p AD=18.2p PS=18.6u PD=18.6u
* device instance $4 r0 *1 35,16 NMOS
XM$4 \$4 B VSS VSS NMOS L=1u W=6.5u AS=18.2p AD=18.2p PS=18.6u PD=18.6u
* device instance $5 r0 *1 90,42 F_RR
XR$5 \$4 Y VDD F_RR R=10.7142857143 L=30u W=2.8u A=84p P=65.6u m=1
* device instance $6 r0 *1 90,78 F_RR
XR$6 \$3 Y VDD F_RR R=10.7142857143 L=30u W=2.8u A=84p P=65.6u m=1
* Estimated lumped wire C to substrate (node 0); not signoff PEX
Ctfwire0 VDD 0 4.97702922e-14
Ctfwire1 \$3 0 1.71889998e-14
Ctfwire2 \$4 0 1.4677706e-14
Ctfwire3 a 0 3.651473e-15
Ctfwire4 b 0 5.132243e-15
Ctfwire5 Y 0 8.5148656e-15
Ctfwire6 \$16 0 1.06938848e-14
Ctfwire7 VSS 0 2.84176108e-14
.ends NOR
