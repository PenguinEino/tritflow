TritFlow ternary testbench
*
.parameters vthMP	= 0
.parameters vthMN 	= 0
.parameters vthMPE      = 0
.parameters vthMNE      = 0
.parameters magRR       = 1
.parameters magRS       = 1
.parameters magCSIO     = 1
.include "/home/ishi-kai/pdk/TR-1um-pinned/libs.tech/spice/models/models_IP62_cap_v5p1.lib"
.include "/home/ishi-kai/pdk/TR-1um-pinned/libs.tech/spice/models/models_IP62_diode_v2.lib"
.include "/home/ishi-kai/pdk/TR-1um-pinned/libs.tech/spice/models/models_IP62_mos_v2.lib"
.include "/home/ishi-kai/pdk/TR-1um-pinned/libs.tech/spice/models/models_IP62_res_v5.lib"
* Public ports renamed from independent taped-out reference
.subckt NANY A B Y VDD VMID VSS
* device instance $1 r0 *1 50,88 PMOS
XM_ex_1 n_ex_7 A Y VDD PMOS L=1u W=14u AS=39.2p AD=39.2p PS=33.6u PD=33.6u
* device instance $2 r0 *1 65,88 PMOS
XM_ex_2 n_ex_10 B Y VDD PMOS L=1u W=14u AS=39.2p AD=39.2p PS=33.6u PD=33.6u
* device instance $3 r0 *1 20,88 PMOS
XM_ex_3 n_ex_32 A VDD VDD PMOS L=1u W=34u AS=95.2p AD=95.2p PS=73.6u PD=73.6u
* device instance $4 r0 *1 35,88 PMOS
XM_ex_4 n_ex_3 B n_ex_32 VDD PMOS L=1u W=34u AS=95.2p AD=95.2p PS=73.6u PD=73.6u
* device instance $5 r0 *1 50,15 NMOS
XM_ex_5 n_ex_7 B VMID VSS NMOS L=1u W=8u AS=22.4p AD=22.4p PS=21.6u PD=21.6u
* device instance $6 r0 *1 65,15 NMOS
XM_ex_6 n_ex_10 A VMID VSS NMOS L=1u W=8u AS=22.4p AD=22.4p PS=21.6u PD=21.6u
* device instance $7 r0 *1 20,15 NMOS
XM_ex_7 n_ex_33 A n_ex_4 VSS NMOS L=1u W=11u AS=30.8p AD=30.8p PS=27.6u PD=27.6u
* device instance $8 r0 *1 35,15 NMOS
XM_ex_8 VSS B n_ex_33 VSS NMOS L=1u W=11u AS=30.8p AD=30.8p PS=27.6u PD=27.6u
* device instance $9 r0 *1 112.5,42 F_RR
XR_ex_9 n_ex_4 Y VDD F_RR R=10.7142857143 L=30u W=2.8u A=84p P=65.6u m=1
* device instance $10 r0 *1 112.5,72 F_RR
XR_ex_10 n_ex_3 Y VDD F_RR R=10.7142857143 L=30u W=2.8u A=84p P=65.6u m=1
* Estimated lumped wire C to substrate (node 0); not signoff PEX
Ctfwire0 VDD 0 5.00961732e-14
Ctfwire1 n_ex_3 0 1.73473818e-14
Ctfwire2 n_ex_4 0 1.52914248e-14
Ctfwire3 Y 0 2.8933305e-14
Ctfwire4 VMID 0 1.8007801e-14
Ctfwire5 n_ex_7 0 1.3524332e-14
Ctfwire6 n_ex_10 0 1.3524332e-14
Ctfwire7 A 0 1.91278484e-14
Ctfwire8 B 0 1.58847588e-14
Ctfwire9 n_ex_32 0 9.6556608e-15
Ctfwire10 n_ex_33 0 3.9454288e-15
Ctfwire11 VSS 0 3.02584622e-14
.ends NANY

.temp 27
.options rshunt=1e12
VDD VDD 0 5
VMID VMID 0 0
VSS VSS 0 -5
Xdut A B Y VDD VMID VSS NANY
Vin0 A 0 PWL(0 -5 1.02e-07 -5 1.03e-07 5 2.02e-07 5 2.03e-07 5 3.02e-07 5 3.03e-07 5 4.02e-07 5 4.03e-07 5 5.02e-07 5 5.03e-07 5 6.02e-07 5 6.03e-07 0 7.02e-07 0 7.03e-07 5 8.02e-07 5 8.03e-07 0 9.02e-07 0 9.03e-07 5 1.002e-06 5 1.003e-06 0 1.102e-06 0 1.103e-06 5 1.202e-06 5 1.203e-06 -5 1.302e-06 -5 1.303e-06 5 1.402e-06 5 1.403e-06 -5 1.502e-06 -5 1.503e-06 5 1.602e-06 5 1.603e-06 -5 1.702e-06 -5 1.703e-06 5 1.802e-06 5 1.803e-06 5 1.902e-06 5 1.903e-06 5 2.002e-06 5 2.003e-06 0 2.102e-06 0 2.103e-06 5 2.202e-06 5 2.203e-06 0 2.302e-06 0 2.303e-06 5 2.402e-06 5 2.403e-06 0 2.502e-06 0 2.503e-06 5 2.602e-06 5 2.603e-06 -5 2.702e-06 -5 2.703e-06 5 2.802e-06 5 2.803e-06 -5 2.902e-06 -5 2.903e-06 5 3.002e-06 5 3.003e-06 -5 3.102e-06 -5 3.103e-06 5 3.202e-06 5 3.203e-06 0 3.302e-06 0 3.303e-06 5 3.402e-06 5 3.403e-06 0 3.502e-06 0 3.503e-06 5 3.602e-06 5 3.603e-06 0 3.702e-06 0 3.703e-06 5 3.802e-06 5 3.803e-06 -5 3.902e-06 -5 3.903e-06 5 4.002e-06 5 4.003e-06 -5 4.102e-06 -5 4.103e-06 5 4.202e-06 5 4.203e-06 -5 4.302e-06 -5 4.303e-06 0 4.402e-06 0 4.403e-06 0 4.502e-06 0 4.503e-06 0 4.602e-06 0 4.603e-06 0 4.702e-06 0 4.703e-06 0 4.802e-06 0 4.803e-06 -5 4.902e-06 -5 4.903e-06 0 5.002e-06 0 5.003e-06 -5 5.102e-06 -5 5.103e-06 0 5.202e-06 0 5.203e-06 -5 5.302e-06 -5 5.303e-06 0 5.402e-06 0 5.403e-06 0 5.502e-06 0 5.503e-06 0 5.602e-06 0 5.603e-06 -5 5.702e-06 -5 5.703e-06 0 5.802e-06 0 5.803e-06 -5 5.902e-06 -5 5.903e-06 0 6.002e-06 0 6.003e-06 -5 6.102e-06 -5 6.103e-06 0 6.202e-06 0 6.203e-06 -5 6.302e-06 -5 6.303e-06 0 6.402e-06 0 6.403e-06 -5 6.502e-06 -5 6.503e-06 0 6.602e-06 0 6.603e-06 -5 6.702e-06 -5 6.703e-06 -5 6.802e-06 -5 6.803e-06 -5 6.902e-06 -5 6.903e-06 -5 7.002e-06 -5 7.003e-06 -5 7.102e-06 -5 7.103e-06 -5 7.202e-06 -5 7.203e-06 -5)
Vin1 B 0 PWL(0 -5 1e-07 -5 1.01e-07 5 2e-07 5 2.01e-07 0 3e-07 0 3.01e-07 5 4e-07 5 4.01e-07 -5 5e-07 -5 5.01e-07 5 6e-07 5 6.01e-07 5 7e-07 5 7.01e-07 5 8e-07 5 8.01e-07 0 9e-07 0 9.01e-07 5 1e-06 5 1.001e-06 -5 1.1e-06 -5 1.101e-06 5 1.2e-06 5 1.201e-06 5 1.3e-06 5 1.301e-06 5 1.4e-06 5 1.401e-06 0 1.5e-06 0 1.501e-06 5 1.6e-06 5 1.601e-06 -5 1.7e-06 -5 1.701e-06 0 1.8e-06 0 1.801e-06 -5 1.9e-06 -5 1.901e-06 0 2e-06 0 2.001e-06 5 2.1e-06 5 2.101e-06 0 2.2e-06 0 2.201e-06 0 2.3e-06 0 2.301e-06 0 2.4e-06 0 2.401e-06 -5 2.5e-06 -5 2.501e-06 0 2.6e-06 0 2.601e-06 5 2.7e-06 5 2.701e-06 0 2.8e-06 0 2.801e-06 0 2.9e-06 0 2.901e-06 0 3e-06 0 3.001e-06 -5 3.1e-06 -5 3.101e-06 -5 3.2e-06 -5 3.201e-06 5 3.3e-06 5 3.301e-06 -5 3.4e-06 -5 3.401e-06 0 3.5e-06 0 3.501e-06 -5 3.6e-06 -5 3.601e-06 -5 3.7e-06 -5 3.701e-06 -5 3.8e-06 -5 3.801e-06 5 3.9e-06 5 3.901e-06 -5 4e-06 -5 4.001e-06 0 4.1e-06 0 4.101e-06 -5 4.2e-06 -5 4.201e-06 -5 4.3e-06 -5 4.301e-06 5 4.4e-06 5 4.401e-06 0 4.5e-06 0 4.501e-06 5 4.6e-06 5 4.601e-06 -5 4.7e-06 -5 4.701e-06 5 4.8e-06 5 4.801e-06 5 4.9e-06 5 4.901e-06 5 5e-06 5 5.001e-06 0 5.1e-06 0 5.101e-06 5 5.2e-06 5 5.201e-06 -5 5.3e-06 -5 5.301e-06 0 5.4e-06 0 5.401e-06 -5 5.5e-06 -5 5.501e-06 0 5.6e-06 0 5.601e-06 5 5.7e-06 5 5.701e-06 0 5.8e-06 0 5.801e-06 0 5.9e-06 0 5.901e-06 0 6e-06 0 6.001e-06 -5 6.1e-06 -5 6.101e-06 -5 6.2e-06 -5 6.201e-06 5 6.3e-06 5 6.301e-06 -5 6.4e-06 -5 6.401e-06 0 6.5e-06 0 6.501e-06 -5 6.6e-06 -5 6.601e-06 -5 6.7e-06 -5 6.701e-06 5 6.8e-06 5 6.801e-06 0 6.9e-06 0 6.901e-06 5 7e-06 5 7.001e-06 -5 7.1e-06 -5 7.101e-06 0 7.2e-06 0 7.201e-06 -5)
Cload0 Y 0 1e-14
.nodeset v(Y)=5
.nodeset v(xdut.n_ex_7)=0
.nodeset v(xdut.n_ex_10)=0
.nodeset v(xdut.n_ex_32)=5
.nodeset v(xdut.n_ex_3)=5
.nodeset v(xdut.n_ex_33)=-5
.nodeset v(xdut.n_ex_4)=-5
.control
set noaskquit
set wr_singlescale
set wr_vecnames
set numdgt=15
tran 1e-10 7.3e-06 0 1e-10
wrdata waveform.txt v(A) v(B) v(Y) i(vdd) i(vmid) i(vss)
quit
.endc
.end
