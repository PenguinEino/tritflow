TritFlow ternary testbench
*
.parameters vthMP	= 0
.parameters vthMN 	= 0
.parameters vthMPE      = 0
.parameters vthMNE      = 0
.parameters magRR       = 1
.parameters magRS       = 1
.parameters magCSIO     = 1
.include "/home/ishi-kai/pdk/TR-1um/libs.tech/spice/models/models_IP62_cap_v5p1.lib"
.include "/home/ishi-kai/pdk/TR-1um/libs.tech/spice/models/models_IP62_diode_v2.lib"
.include "/home/ishi-kai/pdk/TR-1um/libs.tech/spice/models/models_IP62_mos_v2.lib"
.include "/home/ishi-kai/pdk/TR-1um/libs.tech/spice/models/models_IP62_res_v5.lib"
* Public ports renamed from independent taped-out reference
.subckt INV A Y VDD VMID VSS
* device instance $1 r0 *1 13.2,44 PMOS
XM_ex_1 n_ex_4 A VDD VDD PMOS L=1u W=13.5u AS=37.8p AD=37.8p PS=32.6u PD=32.6u
* device instance $2 r0 *1 13.2,14 NMOS
XM_ex_2 n_ex_5 A VSS VSS NMOS L=1u W=5u AS=14p AD=14p PS=15.6u PD=15.6u
* device instance $3 r0 *1 64,32 F_RR
XR_ex_3 n_ex_5 Y VDD F_RR R=10.7142857143 L=30u W=2.8u A=84p P=65.6u m=1
* device instance $4 r0 *1 64,45 F_RR
XR_ex_4 n_ex_4 Y VDD F_RR R=10.7142857143 L=30u W=2.8u A=84p P=65.6u m=1
.ends INV
* Public ports renamed from independent taped-out reference
.subckt NAND A B Y VDD VMID VSS
* device instance $1 r0 *1 20,96 PMOS
XM_ex_1 n_ex_3 A VDD VDD PMOS L=1u W=19u AS=53.2p AD=53.2p PS=43.6u PD=43.6u
* device instance $2 r0 *1 35,96 PMOS
XM_ex_2 n_ex_3 B VDD VDD PMOS L=1u W=19u AS=53.2p AD=53.2p PS=43.6u PD=43.6u
* device instance $3 r0 *1 20,16 NMOS
XM_ex_3 n_ex_16 A n_ex_5 VSS NMOS L=1u W=13u AS=36.4p AD=36.4p PS=31.6u PD=31.6u
* device instance $4 r0 *1 35,16 NMOS
XM_ex_4 VSS B n_ex_16 VSS NMOS L=1u W=13u AS=36.4p AD=36.4p PS=31.6u PD=31.6u
* device instance $5 r0 *1 90,42 F_RR
XR_ex_5 n_ex_5 Y VDD F_RR R=10.7142857143 L=30u W=2.8u A=84p P=65.6u m=1
* device instance $6 r0 *1 90,78 F_RR
XR_ex_6 n_ex_3 Y VDD F_RR R=10.7142857143 L=30u W=2.8u A=84p P=65.6u m=1
.ends NAND
* Public ports renamed from independent taped-out reference
.subckt NOR A B Y VDD VMID VSS
* device instance $1 r0 *1 20,96 PMOS
XM_ex_1 n_ex_16 A VDD VDD PMOS L=1u W=37u AS=103.6p AD=103.6p PS=79.6u PD=79.6u
* device instance $2 r0 *1 35,96 PMOS
XM_ex_2 n_ex_3 B n_ex_16 VDD PMOS L=1u W=37u AS=103.6p AD=103.6p PS=79.6u PD=79.6u
* device instance $3 r0 *1 20,16 NMOS
XM_ex_3 n_ex_4 A VSS VSS NMOS L=1u W=6.5u AS=18.2p AD=18.2p PS=18.6u PD=18.6u
* device instance $4 r0 *1 35,16 NMOS
XM_ex_4 n_ex_4 B VSS VSS NMOS L=1u W=6.5u AS=18.2p AD=18.2p PS=18.6u PD=18.6u
* device instance $5 r0 *1 90,42 F_RR
XR_ex_5 n_ex_4 Y VDD F_RR R=10.7142857143 L=30u W=2.8u A=84p P=65.6u m=1
* device instance $6 r0 *1 90,78 F_RR
XR_ex_6 n_ex_3 Y VDD F_RR R=10.7142857143 L=30u W=2.8u A=84p P=65.6u m=1
.ends NOR
* Public ports renamed from independent taped-out reference
.subckt NANY A B Y VDD VMID VSS
* device instance $1 r0 *1 50,88 PMOS
XM_ex_1 n_ex_7 A Y VDD PMOS L=1u W=14u AS=39.2p AD=39.2p PS=33.6u PD=33.6u
* device instance $2 r0 *1 65,88 PMOS
XM_ex_2 n_ex_10 B Y VDD PMOS L=1u W=14u AS=39.2p AD=39.2p PS=33.6u PD=33.6u
* device instance $3 r0 *1 20,88 PMOS
XM_ex_3 n_ex_32 A VDD VDD PMOS L=1u W=34u AS=95.2p AD=95.2p PS=73.6u PD=73.6u
* device instance $4 r0 *1 35,88 PMOS
XM_ex_4 n_ex_3 B n_ex_32 VDD PMOS L=1u W=34u AS=95.2p AD=95.2p PS=73.6u PD=73.6u
* device instance $5 r0 *1 50,15 NMOS
XM_ex_5 n_ex_7 B VMID VSS NMOS L=1u W=8u AS=22.4p AD=22.4p PS=21.6u PD=21.6u
* device instance $6 r0 *1 65,15 NMOS
XM_ex_6 n_ex_10 A VMID VSS NMOS L=1u W=8u AS=22.4p AD=22.4p PS=21.6u PD=21.6u
* device instance $7 r0 *1 20,15 NMOS
XM_ex_7 n_ex_33 A n_ex_4 VSS NMOS L=1u W=11u AS=30.8p AD=30.8p PS=27.6u PD=27.6u
* device instance $8 r0 *1 35,15 NMOS
XM_ex_8 VSS B n_ex_33 VSS NMOS L=1u W=11u AS=30.8p AD=30.8p PS=27.6u PD=27.6u
* device instance $9 r0 *1 112.5,42 F_RR
XR_ex_9 n_ex_4 Y VDD F_RR R=10.7142857143 L=30u W=2.8u A=84p P=65.6u m=1
* device instance $10 r0 *1 112.5,72 F_RR
XR_ex_10 n_ex_3 Y VDD F_RR R=10.7142857143 L=30u W=2.8u A=84p P=65.6u m=1
.ends NANY
.subckt BUF A Y VDD VMID VSS
Xstage0_M_ex_1 stage0_n_ex_4 A VDD VDD PMOS L=1u W=13.5u AS=37.8p AD=37.8p PS=32.6u PD=32.6u
Xstage0_M_ex_2 stage0_n_ex_5 A VSS VSS NMOS L=1u W=5u AS=14p AD=14p PS=15.6u PD=15.6u
Xstage0_R_ex_3 stage0_n_ex_5 mid VDD F_RR R=10.7142857143 L=30u W=2.8u A=84p P=65.6u m=1
Xstage0_R_ex_4 stage0_n_ex_4 mid VDD F_RR R=10.7142857143 L=30u W=2.8u A=84p P=65.6u m=1
Xstage1_M_ex_1 stage1_n_ex_4 mid VDD VDD PMOS L=1u W=13.5u AS=37.8p AD=37.8p PS=32.6u PD=32.6u
Xstage1_M_ex_2 stage1_n_ex_5 mid VSS VSS NMOS L=1u W=5u AS=14p AD=14p PS=15.6u PD=15.6u
Xstage1_R_ex_3 stage1_n_ex_5 Y VDD F_RR R=10.7142857143 L=30u W=2.8u A=84p P=65.6u m=1
Xstage1_R_ex_4 stage1_n_ex_4 Y VDD F_RR R=10.7142857143 L=30u W=2.8u A=84p P=65.6u m=1
.ends BUF

.subckt CASCADE A a1 a2 a3 a4 a5 a6 b1 b2 b3 b4 b5 b6 tied1 tied2 tied3 tied4 tied5 tied6 VDD VMID VSS
Xstage_a1 A VMID a1 VDD VMID VSS NANY
Xstage_a2 a1 VMID a2 VDD VMID VSS NANY
Xstage_a3 a2 VMID a3 VDD VMID VSS NANY
Xstage_a4 a3 VMID a4 VDD VMID VSS NANY
Xstage_a5 a4 VMID a5 VDD VMID VSS NANY
Xstage_a6 a5 VMID a6 VDD VMID VSS NANY
Xstage_b1 VMID A b1 VDD VMID VSS NANY
Xstage_b2 VMID b1 b2 VDD VMID VSS NANY
Xstage_b3 VMID b2 b3 VDD VMID VSS NANY
Xstage_b4 VMID b3 b4 VDD VMID VSS NANY
Xstage_b5 VMID b4 b5 VDD VMID VSS NANY
Xstage_b6 VMID b5 b6 VDD VMID VSS NANY
Xstage_tied1 A A tied1 VDD VMID VSS NANY
Xstage_tied2 tied1 tied1 tied2 VDD VMID VSS NANY
Xstage_tied3 tied2 tied2 tied3 VDD VMID VSS NANY
Xstage_tied4 tied3 tied3 tied4 VDD VMID VSS NANY
Xstage_tied5 tied4 tied4 tied5 VDD VMID VSS NANY
Xstage_tied6 tied5 tied5 tied6 VDD VMID VSS NANY
.ends CASCADE

.temp 27
.options rshunt=1e12
VDD VDD 0 5
VMID VMID 0 0
VSS VSS 0 -5
Xdut A a1 a2 a3 a4 a5 a6 b1 b2 b3 b4 b5 b6 tied1 tied2 tied3 tied4 tied5 tied6 VDD VMID VSS CASCADE
Vin0 A 0 PWL(0 -5.0 2e-07 -5.0 2.01e-07 0.0 4e-07 0.0 4.01e-07 5.0 6e-07 5.0 6.01e-07 0.0 8e-07 0.0 8.01e-07 -5.0 1e-06 -5.0 1.001e-06 5.0 1.2e-06 5.0 1.201e-06 -5.0 1.4e-06 -5.0 1.401e-06 -1.0 1.6e-06 -1.0 1.601e-06 -0.5 1.8e-06 -0.5 1.801e-06 -0.2 2e-06 -0.2 2.001e-06 0.0 2.2e-06 0.0 2.201e-06 0.2 2.4e-06 0.2 2.401e-06 0.5 2.6e-06 0.5 2.601e-06 1.0 2.8e-06 1.0 2.801e-06 0.0)
Cload5 a6 0 1e-14
Cload11 b6 0 1e-14
Cload17 tied6 0 1e-14
.nodeset v(a1)=5
.nodeset v(a2)=-5
.nodeset v(a3)=5
.nodeset v(a4)=-5
.nodeset v(a5)=5
.nodeset v(a6)=-5
.nodeset v(b1)=5
.nodeset v(b2)=-5
.nodeset v(b3)=5
.nodeset v(b4)=-5
.nodeset v(b5)=5
.nodeset v(b6)=-5
.nodeset v(tied1)=5
.nodeset v(tied2)=-5
.nodeset v(tied3)=5
.nodeset v(tied4)=-5
.nodeset v(tied5)=5
.nodeset v(tied6)=-5
.nodeset v(xdut.xstage_a1.n_ex_7)=4.99999768705584
.nodeset v(xdut.xstage_a1.n_ex_10)=5.00000737901735
.nodeset v(xdut.xstage_a1.n_ex_32)=4.99999991992284
.nodeset v(xdut.xstage_a1.n_ex_3)=4.99999981580822
.nodeset v(xdut.xstage_a1.n_ex_33)=-4.99999991864555
.nodeset v(xdut.xstage_a1.n_ex_4)=4.99999577909056
.nodeset v(xdut.xstage_a2.n_ex_7)=0.000555808075463384
.nodeset v(xdut.xstage_a2.n_ex_10)=1.5008937552374e-12
.nodeset v(xdut.xstage_a2.n_ex_32)=1.17640855077394
.nodeset v(xdut.xstage_a2.n_ex_3)=-4.99999886505289
.nodeset v(xdut.xstage_a2.n_ex_33)=-4.99999996184091
.nodeset v(xdut.xstage_a2.n_ex_4)=-4.99999993538087
.nodeset v(xdut.xstage_a3.n_ex_7)=4.99999768705584
.nodeset v(xdut.xstage_a3.n_ex_10)=5.00000737901735
.nodeset v(xdut.xstage_a3.n_ex_32)=4.99999991992284
.nodeset v(xdut.xstage_a3.n_ex_3)=4.99999981580822
.nodeset v(xdut.xstage_a3.n_ex_33)=-4.99999991864555
.nodeset v(xdut.xstage_a3.n_ex_4)=4.99999577909056
.nodeset v(xdut.xstage_a4.n_ex_7)=0.000555808075463384
.nodeset v(xdut.xstage_a4.n_ex_10)=1.5008937552374e-12
.nodeset v(xdut.xstage_a4.n_ex_32)=1.17640855077394
.nodeset v(xdut.xstage_a4.n_ex_3)=-4.99999886505289
.nodeset v(xdut.xstage_a4.n_ex_33)=-4.99999996184091
.nodeset v(xdut.xstage_a4.n_ex_4)=-4.99999993538087
.nodeset v(xdut.xstage_a5.n_ex_7)=4.99999768705584
.nodeset v(xdut.xstage_a5.n_ex_10)=5.00000737901735
.nodeset v(xdut.xstage_a5.n_ex_32)=4.99999991992284
.nodeset v(xdut.xstage_a5.n_ex_3)=4.99999981580822
.nodeset v(xdut.xstage_a5.n_ex_33)=-4.99999991864555
.nodeset v(xdut.xstage_a5.n_ex_4)=4.99999577909056
.nodeset v(xdut.xstage_a6.n_ex_7)=0.000555808075463384
.nodeset v(xdut.xstage_a6.n_ex_10)=1.5008937552374e-12
.nodeset v(xdut.xstage_a6.n_ex_32)=1.17640855077394
.nodeset v(xdut.xstage_a6.n_ex_3)=-4.99999886505289
.nodeset v(xdut.xstage_a6.n_ex_33)=-4.99999996184091
.nodeset v(xdut.xstage_a6.n_ex_4)=-4.99999993538087
.nodeset v(xdut.xstage_b1.n_ex_7)=5.00000885369907
.nodeset v(xdut.xstage_b1.n_ex_10)=4.99999925248846
.nodeset v(xdut.xstage_b1.n_ex_32)=4.99999996004357
.nodeset v(xdut.xstage_b1.n_ex_3)=4.99999993190372
.nodeset v(xdut.xstage_b1.n_ex_33)=-0.725316966537582
.nodeset v(xdut.xstage_b1.n_ex_4)=4.99999879156585
.nodeset v(xdut.xstage_b2.n_ex_7)=1.50089375523721e-12
.nodeset v(xdut.xstage_b2.n_ex_10)=0.000555808075463384
.nodeset v(xdut.xstage_b2.n_ex_32)=4.99999998497261
.nodeset v(xdut.xstage_b2.n_ex_3)=-4.99999885407861
.nodeset v(xdut.xstage_b2.n_ex_33)=-4.99999997137688
.nodeset v(xdut.xstage_b2.n_ex_4)=-4.99999993543167
.nodeset v(xdut.xstage_b3.n_ex_7)=5.00000885369907
.nodeset v(xdut.xstage_b3.n_ex_10)=4.99999925248846
.nodeset v(xdut.xstage_b3.n_ex_32)=4.99999996004357
.nodeset v(xdut.xstage_b3.n_ex_3)=4.99999993190372
.nodeset v(xdut.xstage_b3.n_ex_33)=-0.725316966537582
.nodeset v(xdut.xstage_b3.n_ex_4)=4.99999879156585
.nodeset v(xdut.xstage_b4.n_ex_7)=1.50089375523721e-12
.nodeset v(xdut.xstage_b4.n_ex_10)=0.000555808075463384
.nodeset v(xdut.xstage_b4.n_ex_32)=4.99999998497261
.nodeset v(xdut.xstage_b4.n_ex_3)=-4.99999885407861
.nodeset v(xdut.xstage_b4.n_ex_33)=-4.99999997137688
.nodeset v(xdut.xstage_b4.n_ex_4)=-4.99999993543167
.nodeset v(xdut.xstage_b5.n_ex_7)=5.00000885369907
.nodeset v(xdut.xstage_b5.n_ex_10)=4.99999925248846
.nodeset v(xdut.xstage_b5.n_ex_32)=4.99999996004357
.nodeset v(xdut.xstage_b5.n_ex_3)=4.99999993190372
.nodeset v(xdut.xstage_b5.n_ex_33)=-0.725316966537582
.nodeset v(xdut.xstage_b5.n_ex_4)=4.99999879156585
.nodeset v(xdut.xstage_b6.n_ex_7)=1.50089375523721e-12
.nodeset v(xdut.xstage_b6.n_ex_10)=0.000555808075463384
.nodeset v(xdut.xstage_b6.n_ex_32)=4.99999998497261
.nodeset v(xdut.xstage_b6.n_ex_3)=-4.99999885407861
.nodeset v(xdut.xstage_b6.n_ex_33)=-4.99999997137688
.nodeset v(xdut.xstage_b6.n_ex_4)=-4.99999993543167
.nodeset v(xdut.xstage_tied1.n_ex_7)=4.99999935556322
.nodeset v(xdut.xstage_tied1.n_ex_10)=4.99999935556322
.nodeset v(xdut.xstage_tied1.n_ex_32)=4.99999997606611
.nodeset v(xdut.xstage_tied1.n_ex_3)=4.99999995400508
.nodeset v(xdut.xstage_tied1.n_ex_33)=-4.82086628472659
.nodeset v(xdut.xstage_tied1.n_ex_4)=4.99999916533387
.nodeset v(xdut.xstage_tied2.n_ex_7)=1.50089383341904e-12
.nodeset v(xdut.xstage_tied2.n_ex_10)=1.50089383341904e-12
.nodeset v(xdut.xstage_tied2.n_ex_32)=4.94744025483034
.nodeset v(xdut.xstage_tied2.n_ex_3)=-4.99999926169509
.nodeset v(xdut.xstage_tied2.n_ex_33)=-4.99999997853434
.nodeset v(xdut.xstage_tied2.n_ex_4)=-4.99999995897302
.nodeset v(xdut.xstage_tied3.n_ex_7)=4.99999935556322
.nodeset v(xdut.xstage_tied3.n_ex_10)=4.99999935556322
.nodeset v(xdut.xstage_tied3.n_ex_32)=4.99999997606611
.nodeset v(xdut.xstage_tied3.n_ex_3)=4.99999995400508
.nodeset v(xdut.xstage_tied3.n_ex_33)=-4.82086628472659
.nodeset v(xdut.xstage_tied3.n_ex_4)=4.99999916533387
.nodeset v(xdut.xstage_tied4.n_ex_7)=1.50089383341904e-12
.nodeset v(xdut.xstage_tied4.n_ex_10)=1.50089383341904e-12
.nodeset v(xdut.xstage_tied4.n_ex_32)=4.94744025483034
.nodeset v(xdut.xstage_tied4.n_ex_3)=-4.99999926169509
.nodeset v(xdut.xstage_tied4.n_ex_33)=-4.99999997853434
.nodeset v(xdut.xstage_tied4.n_ex_4)=-4.99999995897302
.nodeset v(xdut.xstage_tied5.n_ex_7)=4.99999935556322
.nodeset v(xdut.xstage_tied5.n_ex_10)=4.99999935556322
.nodeset v(xdut.xstage_tied5.n_ex_32)=4.99999997606611
.nodeset v(xdut.xstage_tied5.n_ex_3)=4.99999995400508
.nodeset v(xdut.xstage_tied5.n_ex_33)=-4.82086628472659
.nodeset v(xdut.xstage_tied5.n_ex_4)=4.99999916533387
.nodeset v(xdut.xstage_tied6.n_ex_7)=1.50089383341904e-12
.nodeset v(xdut.xstage_tied6.n_ex_10)=1.50089383341904e-12
.nodeset v(xdut.xstage_tied6.n_ex_32)=4.94744025483034
.nodeset v(xdut.xstage_tied6.n_ex_3)=-4.99999926169509
.nodeset v(xdut.xstage_tied6.n_ex_33)=-4.99999997853434
.nodeset v(xdut.xstage_tied6.n_ex_4)=-4.99999995897302
.control
set noaskquit
set wr_singlescale
set wr_vecnames
set numdgt=15
tran 2e-10 3e-06 0 2e-10
wrdata waveform.txt v(A) v(a1) v(a2) v(a3) v(a4) v(a5) v(a6) v(b1) v(b2) v(b3) v(b4) v(b5) v(b6) v(tied1) v(tied2) v(tied3) v(tied4) v(tied5) v(tied6) i(vdd) i(vmid) i(vss)
quit
.endc
.end
