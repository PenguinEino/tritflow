* PDK extraction; public ports normalized, no parasitic RC
.subckt BUF A Y VDD VMID VSS
* device instance $1 r0 *1 19.2,56 PMOS
XM_ex_1 n_ex_5 tfpg_1 VDD VDD PMOS L=1u W=13.5u AS=37.8p AD=37.8p PS=32.6u PD=32.6u
* device instance $2 r0 *1 127.2,56 PMOS
XM_ex_2 n_ex_8 tfpg_2 VDD VDD PMOS L=1u W=13.5u AS=37.8p AD=37.8p PS=32.6u PD=32.6u
* device instance $3 r0 *1 19.2,26 NMOS
XM_ex_3 n_ex_6 tfpg_3 VSS VSS NMOS L=1u W=5u AS=14p AD=14p PS=15.6u PD=15.6u
* device instance $4 r0 *1 127.2,26 NMOS
XM_ex_4 n_ex_9 tfpg_4 VSS VSS NMOS L=1u W=5u AS=14p AD=14p PS=15.6u PD=15.6u
* device instance $5 r0 *1 70,44 F_RR
XR_ex_5 n_ex_6 n_ex_7 VDD F_RR R=10.7142857143 L=30u W=2.8u A=84p P=65.6u m=1
* device instance $6 r0 *1 70,57 F_RR
XR_ex_6 n_ex_5 n_ex_7 VDD F_RR R=10.7142857143 L=30u W=2.8u A=84p P=65.6u m=1
* device instance $7 r0 *1 178,44 F_RR
XR_ex_7 n_ex_9 Y VDD F_RR R=10.7142857143 L=30u W=2.8u A=84p P=65.6u m=1
* device instance $8 r0 *1 178,57 F_RR
XR_ex_8 n_ex_8 Y VDD F_RR R=10.7142857143 L=30u W=2.8u A=84p P=65.6u m=1

* Gate-field-poly sheet-R sensitivity; uncalibrated GC proxy
Rtfpg_0 A tfpg_1 1411.4265596699
Rtfpg_1 A tfpg_3 960.088781401028
Rtfpg_2 tfpg_1 tfpg_3 797727.043634104
Rtfpg_3 n_ex_7 tfpg_2 1411.4265596699
Rtfpg_4 n_ex_7 tfpg_4 960.088781401028
Rtfpg_5 tfpg_2 tfpg_4 797727.043634104
.ends BUF
