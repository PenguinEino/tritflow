TritFlow ternary testbench
*
.parameters vthMP	= 0
.parameters vthMN 	= 0
.parameters vthMPE      = 0
.parameters vthMNE      = 0
.parameters magRR       = 1
.parameters magRS       = 1
.parameters magCSIO     = 1
.include "/home/ishi-kai/pdk/TR-1um/libs.tech/spice/models/models_IP62_cap_v5p1.lib"
.include "/home/ishi-kai/pdk/TR-1um/libs.tech/spice/models/models_IP62_diode_v2.lib"
.include "/home/ishi-kai/pdk/TR-1um/libs.tech/spice/models/models_IP62_mos_v2.lib"
.include "/home/ishi-kai/pdk/TR-1um/libs.tech/spice/models/models_IP62_res_v5.lib"
* PDK extraction; public ports normalized, no parasitic RC
.subckt NOR A B Y VDD VMID VSS
* device instance $1 r0 *1 26,100 PMOS
XM_ex_1 n_ex_18 tfpg_1 VDD VDD PMOS L=1u W=37u AS=103.6p AD=103.6p PS=79.6u PD=79.6u
* device instance $2 r0 *1 41,100 PMOS
XM_ex_2 n_ex_4 tfpg_2 n_ex_18 VDD PMOS L=1u W=37u AS=103.6p AD=103.6p PS=79.6u PD=79.6u
* device instance $3 r0 *1 26,28 NMOS
XM_ex_3 n_ex_5 tfpg_3 VSS VSS NMOS L=1u W=6.5u AS=18.2p AD=18.2p PS=18.6u PD=18.6u
* device instance $4 r0 *1 41,28 NMOS
XM_ex_4 n_ex_5 tfpg_4 VSS VSS NMOS L=1u W=6.5u AS=18.2p AD=18.2p PS=18.6u PD=18.6u
* device instance $5 r0 *1 96,54 F_RR
XR_ex_5 n_ex_5 Y VDD F_RR R=10.7142857143 L=30u W=2.8u A=84p P=65.6u m=1
* device instance $6 r0 *1 96,84 F_RR
XR_ex_6 n_ex_4 Y VDD F_RR R=10.7142857143 L=30u W=2.8u A=84p P=65.6u m=1

* Gate-field-poly sheet-R sensitivity; uncalibrated GC proxy
Rtfpg_0 A tfpg_1 2760.42049519312
Rtfpg_1 A tfpg_3 3150.86993089646
Rtfpg_2 tfpg_1 tfpg_3 5129550.78763352
Rtfpg_3 B tfpg_2 2039.8289212419
Rtfpg_4 B tfpg_4 3872.15173865988
Rtfpg_5 tfpg_2 tfpg_4 4657673.27350066
.ends NOR

.temp 27
.options rshunt=1e12
VDD VDD 0 5
VMID VMID 0 0
VSS VSS 0 -5
Xdut A B Y VDD VMID VSS NOR
Vin0 A 0 PWL(0 -5 4.5e-07 -5 6e-07 5 9e-07 5 1.05e-06 5 1.35e-06 5 1.5e-06 5 1.8e-06 5 1.95e-06 5 2.25e-06 5 2.4e-06 5 2.7e-06 5 2.85e-06 0 3.15e-06 0 3.3e-06 5 3.6e-06 5 3.75e-06 0 4.05e-06 0 4.2e-06 5 4.5e-06 5 4.65e-06 0 4.95e-06 0 5.1e-06 5 5.4e-06 5 5.55e-06 -5 5.85e-06 -5 6e-06 5 6.3e-06 5 6.45e-06 -5 6.75e-06 -5 6.9e-06 5 7.2e-06 5 7.35e-06 -5 7.65e-06 -5 7.8e-06 5 8.1e-06 5 8.25e-06 5 8.55e-06 5 8.7e-06 5 9e-06 5 9.15e-06 0 9.45e-06 0 9.6e-06 5 9.9e-06 5 1.005e-05 0 1.035e-05 0 1.05e-05 5 1.08e-05 5 1.095e-05 0 1.125e-05 0 1.14e-05 5 1.17e-05 5 1.185e-05 -5 1.215e-05 -5 1.23e-05 5 1.26e-05 5 1.275e-05 -5 1.305e-05 -5 1.32e-05 5 1.35e-05 5 1.365e-05 -5 1.395e-05 -5 1.41e-05 5 1.44e-05 5 1.455e-05 0 1.485e-05 0 1.5e-05 5 1.53e-05 5 1.545e-05 0 1.575e-05 0 1.59e-05 5 1.62e-05 5 1.635e-05 0 1.665e-05 0 1.68e-05 5 1.71e-05 5 1.725e-05 -5 1.755e-05 -5 1.77e-05 5 1.8e-05 5 1.815e-05 -5 1.845e-05 -5 1.86e-05 5 1.89e-05 5 1.905e-05 -5 1.935e-05 -5 1.95e-05 0 1.98e-05 0 1.995e-05 0 2.025e-05 0 2.04e-05 0 2.07e-05 0 2.085e-05 0 2.115e-05 0 2.13e-05 0 2.16e-05 0 2.175e-05 -5 2.205e-05 -5 2.22e-05 0 2.25e-05 0 2.265e-05 -5 2.295e-05 -5 2.31e-05 0 2.34e-05 0 2.355e-05 -5 2.385e-05 -5 2.4e-05 0 2.43e-05 0 2.445e-05 0 2.475e-05 0 2.49e-05 0 2.52e-05 0 2.535e-05 -5 2.565e-05 -5 2.58e-05 0 2.61e-05 0 2.625e-05 -5 2.655e-05 -5 2.67e-05 0 2.7e-05 0 2.715e-05 -5 2.745e-05 -5 2.76e-05 0 2.79e-05 0 2.805e-05 -5 2.835e-05 -5 2.85e-05 0 2.88e-05 0 2.895e-05 -5 2.925e-05 -5 2.94e-05 0 2.97e-05 0 2.985e-05 -5 3.015e-05 -5 3.03e-05 -5 3.06e-05 -5 3.075e-05 -5 3.105e-05 -5 3.12e-05 -5 3.15e-05 -5 3.165e-05 -5 3.195e-05 -5 3.21e-05 -5 3.24e-05 -5 3.255e-05 -5)
Vin1 B 0 PWL(0 -5 4.5e-07 -5 6e-07 5 9e-07 5 1.05e-06 0 1.35e-06 0 1.5e-06 5 1.8e-06 5 1.95e-06 -5 2.25e-06 -5 2.4e-06 5 2.7e-06 5 2.85e-06 5 3.15e-06 5 3.3e-06 5 3.6e-06 5 3.75e-06 0 4.05e-06 0 4.2e-06 5 4.5e-06 5 4.65e-06 -5 4.95e-06 -5 5.1e-06 5 5.4e-06 5 5.55e-06 5 5.85e-06 5 6e-06 5 6.3e-06 5 6.45e-06 0 6.75e-06 0 6.9e-06 5 7.2e-06 5 7.35e-06 -5 7.65e-06 -5 7.8e-06 0 8.1e-06 0 8.25e-06 -5 8.55e-06 -5 8.7e-06 0 9e-06 0 9.15e-06 5 9.45e-06 5 9.6e-06 0 9.9e-06 0 1.005e-05 0 1.035e-05 0 1.05e-05 0 1.08e-05 0 1.095e-05 -5 1.125e-05 -5 1.14e-05 0 1.17e-05 0 1.185e-05 5 1.215e-05 5 1.23e-05 0 1.26e-05 0 1.275e-05 0 1.305e-05 0 1.32e-05 0 1.35e-05 0 1.365e-05 -5 1.395e-05 -5 1.41e-05 -5 1.44e-05 -5 1.455e-05 5 1.485e-05 5 1.5e-05 -5 1.53e-05 -5 1.545e-05 0 1.575e-05 0 1.59e-05 -5 1.62e-05 -5 1.635e-05 -5 1.665e-05 -5 1.68e-05 -5 1.71e-05 -5 1.725e-05 5 1.755e-05 5 1.77e-05 -5 1.8e-05 -5 1.815e-05 0 1.845e-05 0 1.86e-05 -5 1.89e-05 -5 1.905e-05 -5 1.935e-05 -5 1.95e-05 5 1.98e-05 5 1.995e-05 0 2.025e-05 0 2.04e-05 5 2.07e-05 5 2.085e-05 -5 2.115e-05 -5 2.13e-05 5 2.16e-05 5 2.175e-05 5 2.205e-05 5 2.22e-05 5 2.25e-05 5 2.265e-05 0 2.295e-05 0 2.31e-05 5 2.34e-05 5 2.355e-05 -5 2.385e-05 -5 2.4e-05 0 2.43e-05 0 2.445e-05 -5 2.475e-05 -5 2.49e-05 0 2.52e-05 0 2.535e-05 5 2.565e-05 5 2.58e-05 0 2.61e-05 0 2.625e-05 0 2.655e-05 0 2.67e-05 0 2.7e-05 0 2.715e-05 -5 2.745e-05 -5 2.76e-05 -5 2.79e-05 -5 2.805e-05 5 2.835e-05 5 2.85e-05 -5 2.88e-05 -5 2.895e-05 0 2.925e-05 0 2.94e-05 -5 2.97e-05 -5 2.985e-05 -5 3.015e-05 -5 3.03e-05 5 3.06e-05 5 3.075e-05 0 3.105e-05 0 3.12e-05 5 3.15e-05 5 3.165e-05 -5 3.195e-05 -5 3.21e-05 0 3.24e-05 0 3.255e-05 -5)
Cload0 Y 0 1e-13
.nodeset v(Y)=5
.nodeset v(xdut.n_ex_18)=5
.nodeset v(xdut.n_ex_4)=5
.nodeset v(xdut.n_ex_5)=-5
.control
set noaskquit
set wr_singlescale
set wr_vecnames
set numdgt=15
tran 2e-09 3.285e-05 0 2e-09
wrdata waveform.txt v(A) v(B) v(Y) i(vdd) i(vmid) i(vss)
quit
.endc
.end
