TritFlow ternary testbench
*
.parameters vthMP	= 0
.parameters vthMN 	= 0
.parameters vthMPE      = 0
.parameters vthMNE      = 0
.parameters magRR       = 1
.parameters magRS       = 1
.parameters magCSIO     = 1
.include "/home/ishi-kai/pdk/TR-1um/libs.tech/spice/models/models_IP62_cap_v5p1.lib"
.include "/home/ishi-kai/pdk/TR-1um/libs.tech/spice/models/models_IP62_diode_v2.lib"
.include "/home/ishi-kai/pdk/TR-1um/libs.tech/spice/models/models_IP62_mos_v2.lib"
.include "/home/ishi-kai/pdk/TR-1um/libs.tech/spice/models/models_IP62_res_v5.lib"
* PDK extraction; public ports normalized, no parasitic RC
.subckt NANY A B Y VDD VMID VSS
* device instance $1 r0 *1 56,100 PMOS
XM_ex_1 n_ex_7 tfpg_1 Y VDD PMOS L=1u W=14u AS=39.2p AD=39.2p PS=33.6u PD=33.6u
* device instance $2 r0 *1 71,100 PMOS
XM_ex_2 n_ex_9 tfpg_2 Y VDD PMOS L=1u W=14u AS=39.2p AD=39.2p PS=33.6u PD=33.6u
* device instance $3 r0 *1 41,100 PMOS
XM_ex_3 n_ex_30 tfpg_3 n_ex_43 VDD PMOS L=1u W=34u AS=95.2p AD=95.2p PS=73.6u PD=73.6u
* device instance $4 r0 *1 26,100 PMOS
XM_ex_4 n_ex_43 tfpg_4 VDD VDD PMOS L=1u W=34u AS=95.2p AD=95.2p PS=73.6u PD=73.6u
* device instance $5 r0 *1 56,27 NMOS
XM_ex_5 n_ex_7 tfpg_5 VMID VSS NMOS L=1u W=8u AS=22.4p AD=22.4p PS=21.6u PD=21.6u
* device instance $6 r0 *1 71,27 NMOS
XM_ex_6 n_ex_9 tfpg_6 VMID VSS NMOS L=1u W=8u AS=22.4p AD=22.4p PS=21.6u PD=21.6u
* device instance $7 r0 *1 26,27 NMOS
XM_ex_7 n_ex_17 tfpg_7 n_ex_5 VSS NMOS L=1u W=11u AS=30.8p AD=30.8p PS=27.6u PD=27.6u
* device instance $8 r0 *1 41,27 NMOS
XM_ex_8 VSS tfpg_8 n_ex_17 VSS NMOS L=1u W=11u AS=30.8p AD=30.8p PS=27.6u PD=27.6u
* device instance $9 r0 *1 118.5,54 F_RR
XR_ex_9 n_ex_5 Y VDD F_RR R=10.7142857143 L=30u W=2.8u A=84p P=65.6u m=1
* device instance $10 r0 *1 118.5,84 F_RR
XR_ex_10 n_ex_30 Y VDD F_RR R=10.7142857143 L=30u W=2.8u A=84p P=65.6u m=1

* Gate-field-poly sheet-R sensitivity; uncalibrated GC proxy
Rtfpg_0 A tfpg_6 418.936959170296
Rtfpg_1 A tfpg_1 538.936959170295
Rtfpg_2 A tfpg_4 2219.94693623742
Rtfpg_3 A tfpg_7 3721.77615778197
Rtfpg_4 tfpg_4 tfpg_7 4872337.45250838
Rtfpg_5 B tfpg_5 418.936959170296
Rtfpg_6 B tfpg_2 538.936959170295
Rtfpg_7 B tfpg_3 2940.5964657453
Rtfpg_8 B tfpg_8 3000.66496702944
Rtfpg_9 tfpg_3 tfpg_8 5203927.05703418
.ends NANY

.temp 27
.options rshunt=1e12
VDD VDD 0 5
VMID VMID 0 0
VSS VSS 0 -5
Xdut A B Y VDD VMID VSS NANY
Vin0 A 0 PWL(0 -5 3.01e-07 -5 3.02e-07 5 6.02e-07 5 6.03e-07 5 9.03e-07 5 9.04e-07 5 1.204e-06 5 1.205e-06 5 1.505e-06 5 1.506e-06 5 1.806e-06 5 1.807e-06 0 2.107e-06 0 2.108e-06 5 2.408e-06 5 2.409e-06 0 2.709e-06 0 2.71e-06 5 3.01e-06 5 3.011e-06 0 3.311e-06 0 3.312e-06 5 3.612e-06 5 3.613e-06 -5 3.913e-06 -5 3.914e-06 5 4.214e-06 5 4.215e-06 -5 4.515e-06 -5 4.516e-06 5 4.816e-06 5 4.817e-06 -5 5.117e-06 -5 5.118e-06 5 5.418e-06 5 5.419e-06 5 5.719e-06 5 5.72e-06 5 6.02e-06 5 6.021e-06 0 6.321e-06 0 6.322e-06 5 6.622e-06 5 6.623e-06 0 6.923e-06 0 6.924e-06 5 7.224e-06 5 7.225e-06 0 7.525e-06 0 7.526e-06 5 7.826e-06 5 7.827e-06 -5 8.127e-06 -5 8.128e-06 5 8.428e-06 5 8.429e-06 -5 8.729e-06 -5 8.73e-06 5 9.03e-06 5 9.031e-06 -5 9.331e-06 -5 9.332e-06 5 9.632e-06 5 9.633e-06 0 9.933e-06 0 9.934e-06 5 1.0234e-05 5 1.0235e-05 0 1.0535e-05 0 1.0536e-05 5 1.0836e-05 5 1.0837e-05 0 1.1137e-05 0 1.1138e-05 5 1.1438e-05 5 1.1439e-05 -5 1.1739e-05 -5 1.174e-05 5 1.204e-05 5 1.2041e-05 -5 1.2341e-05 -5 1.2342e-05 5 1.2642e-05 5 1.2643e-05 -5 1.2943e-05 -5 1.2944e-05 0 1.3244e-05 0 1.3245e-05 0 1.3545e-05 0 1.3546e-05 0 1.3846e-05 0 1.3847e-05 0 1.4147e-05 0 1.4148e-05 0 1.4448e-05 0 1.4449e-05 -5 1.4749e-05 -5 1.475e-05 0 1.505e-05 0 1.5051e-05 -5 1.5351e-05 -5 1.5352e-05 0 1.5652e-05 0 1.5653e-05 -5 1.5953e-05 -5 1.5954e-05 0 1.6254e-05 0 1.6255e-05 0 1.6555e-05 0 1.6556e-05 0 1.6856e-05 0 1.6857e-05 -5 1.7157e-05 -5 1.7158e-05 0 1.7458e-05 0 1.7459e-05 -5 1.7759e-05 -5 1.776e-05 0 1.806e-05 0 1.8061e-05 -5 1.8361e-05 -5 1.8362e-05 0 1.8662e-05 0 1.8663e-05 -5 1.8963e-05 -5 1.8964e-05 0 1.9264e-05 0 1.9265e-05 -5 1.9565e-05 -5 1.9566e-05 0 1.9866e-05 0 1.9867e-05 -5 2.0167e-05 -5 2.0168e-05 -5 2.0468e-05 -5 2.0469e-05 -5 2.0769e-05 -5 2.077e-05 -5 2.107e-05 -5 2.1071e-05 -5 2.1371e-05 -5 2.1372e-05 -5 2.1672e-05 -5 2.1673e-05 -5)
Vin1 B 0 PWL(0 -5 3.01e-07 -5 3.02e-07 5 6.02e-07 5 6.03e-07 0 9.03e-07 0 9.04e-07 5 1.204e-06 5 1.205e-06 -5 1.505e-06 -5 1.506e-06 5 1.806e-06 5 1.807e-06 5 2.107e-06 5 2.108e-06 5 2.408e-06 5 2.409e-06 0 2.709e-06 0 2.71e-06 5 3.01e-06 5 3.011e-06 -5 3.311e-06 -5 3.312e-06 5 3.612e-06 5 3.613e-06 5 3.913e-06 5 3.914e-06 5 4.214e-06 5 4.215e-06 0 4.515e-06 0 4.516e-06 5 4.816e-06 5 4.817e-06 -5 5.117e-06 -5 5.118e-06 0 5.418e-06 0 5.419e-06 -5 5.719e-06 -5 5.72e-06 0 6.02e-06 0 6.021e-06 5 6.321e-06 5 6.322e-06 0 6.622e-06 0 6.623e-06 0 6.923e-06 0 6.924e-06 0 7.224e-06 0 7.225e-06 -5 7.525e-06 -5 7.526e-06 0 7.826e-06 0 7.827e-06 5 8.127e-06 5 8.128e-06 0 8.428e-06 0 8.429e-06 0 8.729e-06 0 8.73e-06 0 9.03e-06 0 9.031e-06 -5 9.331e-06 -5 9.332e-06 -5 9.632e-06 -5 9.633e-06 5 9.933e-06 5 9.934e-06 -5 1.0234e-05 -5 1.0235e-05 0 1.0535e-05 0 1.0536e-05 -5 1.0836e-05 -5 1.0837e-05 -5 1.1137e-05 -5 1.1138e-05 -5 1.1438e-05 -5 1.1439e-05 5 1.1739e-05 5 1.174e-05 -5 1.204e-05 -5 1.2041e-05 0 1.2341e-05 0 1.2342e-05 -5 1.2642e-05 -5 1.2643e-05 -5 1.2943e-05 -5 1.2944e-05 5 1.3244e-05 5 1.3245e-05 0 1.3545e-05 0 1.3546e-05 5 1.3846e-05 5 1.3847e-05 -5 1.4147e-05 -5 1.4148e-05 5 1.4448e-05 5 1.4449e-05 5 1.4749e-05 5 1.475e-05 5 1.505e-05 5 1.5051e-05 0 1.5351e-05 0 1.5352e-05 5 1.5652e-05 5 1.5653e-05 -5 1.5953e-05 -5 1.5954e-05 0 1.6254e-05 0 1.6255e-05 -5 1.6555e-05 -5 1.6556e-05 0 1.6856e-05 0 1.6857e-05 5 1.7157e-05 5 1.7158e-05 0 1.7458e-05 0 1.7459e-05 0 1.7759e-05 0 1.776e-05 0 1.806e-05 0 1.8061e-05 -5 1.8361e-05 -5 1.8362e-05 -5 1.8662e-05 -5 1.8663e-05 5 1.8963e-05 5 1.8964e-05 -5 1.9264e-05 -5 1.9265e-05 0 1.9565e-05 0 1.9566e-05 -5 1.9866e-05 -5 1.9867e-05 -5 2.0167e-05 -5 2.0168e-05 5 2.0468e-05 5 2.0469e-05 0 2.0769e-05 0 2.077e-05 5 2.107e-05 5 2.1071e-05 -5 2.1371e-05 -5 2.1372e-05 0 2.1672e-05 0 2.1673e-05 -5)
Cload0 Y 0 1e-14
.nodeset v(Y)=5
.nodeset v(xdut.n_ex_7)=0
.nodeset v(xdut.n_ex_9)=0
.nodeset v(xdut.n_ex_30)=5
.nodeset v(xdut.n_ex_43)=5
.nodeset v(xdut.n_ex_17)=-5
.nodeset v(xdut.n_ex_5)=-5
.control
set noaskquit
set wr_singlescale
set wr_vecnames
set numdgt=15
tran 5e-11 2.1973e-05 0 5e-11
wrdata waveform.txt v(A) v(B) v(Y) i(vdd) i(vmid) i(vss)
quit
.endc
.end
