* Created by KLayout
*** My special header ***

* cell FILL_PROBE
* pin VDD
* pin VMID
* pin VSS
* pin YN
* pin YP
* pin YZ
.SUBCKT FILL_PROBE VDD VMID VSS YN YP YZ
* cell instance $1 r0 *1 24,0
X$1 VDD YP TIEP
* cell instance $2 r0 *1 96,0
X$2 VDD YZ VMID TIEZ
* cell instance $3 r0 *1 168,0
X$3 VDD YN VSS TIEN
.ENDS FILL_PROBE

* cell TIEN
* pin VDD
* pin Y
* pin VSS
.SUBCKT TIEN VDD Y VSS
* device instance $1 r0 *1 36,55 F_RR
XR$1 VSS Y VDD F_RR R=10.7142857143 L=30u W=2.8u A=84p P=65.6u m=1
.ENDS TIEN

* cell TIEZ
* pin VDD
* pin Y
* pin VMID
.SUBCKT TIEZ VDD Y VMID
* device instance $1 r0 *1 36,55 F_RR
XR$1 VMID Y VDD F_RR R=10.7142857143 L=30u W=2.8u A=84p P=65.6u m=1
.ENDS TIEZ

* cell TIEP
* pin VDD
* pin Y
.SUBCKT TIEP VDD Y
* device instance $1 r0 *1 36,55 F_RR
XR$1 VDD Y VDD F_RR R=10.7142857143 L=30u W=2.8u A=84p P=65.6u m=1
.ENDS TIEP
