* RR30 schematic connectivity; lengths in micrometres
.subckt TIEP Y VDD VMID VSS
XRT Y VDD VDD F_RR W=2.8u L=30u
.ends TIEP
* RR30 schematic connectivity; lengths in micrometres
.subckt TIEZ Y VDD VMID VSS
XRT Y VMID VDD F_RR W=2.8u L=30u
.ends TIEZ
* RR30 schematic connectivity; lengths in micrometres
.subckt TIEN Y VDD VMID VSS
XRT Y VSS VDD F_RR W=2.8u L=30u
.ends TIEN

.subckt FILL_PROBE YP YZ YN VDD VMID VSS
XTIEP YP VDD VMID VSS TIEP
XTIEZ YZ VDD VMID VSS TIEZ
XTIEN YN VDD VMID VSS TIEN
.ends FILL_PROBE
