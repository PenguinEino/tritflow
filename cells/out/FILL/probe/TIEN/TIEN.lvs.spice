* RR30 schematic connectivity; lengths in micrometres
.subckt TIEN Y VDD VMID VSS
XRT Y VSS VDD F_RR W=2.8u L=30u
.ends TIEN
