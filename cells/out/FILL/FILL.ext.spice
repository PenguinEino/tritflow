* Device-free PDK extraction; rail continuity qualified by FILL_PROBE
.subckt FILL VDD VMID VSS
.ends FILL
