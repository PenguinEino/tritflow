* Public ports renamed from independent taped-out reference
.subckt INV A Y VDD VMID VSS
* device instance $1 r0 *1 13.2,44 PMOS
XM$1 \$4 A VDD VDD PMOS L=1u W=13.5u AS=37.8p AD=37.8p PS=32.6u PD=32.6u
* device instance $2 r0 *1 13.2,14 NMOS
XM$2 \$5 A VSS VSS NMOS L=1u W=5u AS=14p AD=14p PS=15.6u PD=15.6u
* device instance $3 r0 *1 64,32 F_RR
XR$3 \$5 Y VDD F_RR R=10.7142857143 L=30u W=2.8u A=84p P=65.6u m=1
* device instance $4 r0 *1 64,45 F_RR
XR$4 \$4 Y VDD F_RR R=10.7142857143 L=30u W=2.8u A=84p P=65.6u m=1
* Estimated lumped wire C to substrate (node 0); not signoff PEX
Ctfwire0 VDD 0 2.57975434e-14
Ctfwire1 A 0 1.985781e-15
Ctfwire2 \$4 0 6.368421e-15
Ctfwire3 \$5 0 7.536423e-15
Ctfwire4 Y 0 4.5427916e-15
Ctfwire5 VSS 0 1.84650864e-14
.ends INV
