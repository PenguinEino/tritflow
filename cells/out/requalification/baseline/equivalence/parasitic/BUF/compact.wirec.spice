* PDK extraction; public ports normalized, no parasitic RC
.subckt BUF A Y VDD VMID VSS
* device instance $1 r0 *1 19.2,56 PMOS
XM$1 \$5 A VDD VDD PMOS L=1u W=13.5u AS=37.8p AD=37.8p PS=32.6u PD=32.6u
* device instance $2 r0 *1 127.2,56 PMOS
XM$2 \$8 \$7 VDD VDD PMOS L=1u W=13.5u AS=37.8p AD=37.8p PS=32.6u PD=32.6u
* device instance $3 r0 *1 19.2,26 NMOS
XM$3 \$6 A VSS VSS NMOS L=1u W=5u AS=14p AD=14p PS=15.6u PD=15.6u
* device instance $4 r0 *1 127.2,26 NMOS
XM$4 \$9 \$7 VSS VSS NMOS L=1u W=5u AS=14p AD=14p PS=15.6u PD=15.6u
* device instance $5 r0 *1 70,44 F_RR
XR$5 \$6 \$7 VDD F_RR R=10.7142857143 L=30u W=2.8u A=84p P=65.6u m=1
* device instance $6 r0 *1 70,57 F_RR
XR$6 \$5 \$7 VDD F_RR R=10.7142857143 L=30u W=2.8u A=84p P=65.6u m=1
* device instance $7 r0 *1 178,44 F_RR
XR$7 \$9 Y VDD F_RR R=10.7142857143 L=30u W=2.8u A=84p P=65.6u m=1
* device instance $8 r0 *1 178,57 F_RR
XR$8 \$8 Y VDD F_RR R=10.7142857143 L=30u W=2.8u A=84p P=65.6u m=1
* Estimated lumped wire C to substrate (node 0); not signoff PEX
Ctfwire0 VDD 0 1.319545028e-13
Ctfwire1 A 0 3.2210792e-15
Ctfwire2 \$5 0 6.368421e-15
Ctfwire3 \$6 0 7.536423e-15
Ctfwire4 \$7 0 1.16477584e-14
Ctfwire5 \$8 0 6.368421e-15
Ctfwire6 \$9 0 7.536423e-15
Ctfwire7 Y 0 6.030037e-15
Ctfwire8 VSS 0 8.08323826e-14
.ends BUF
