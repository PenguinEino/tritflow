* RR30 schematic connectivity; lengths in micrometres
.subckt NOR A B Y VDD VMID VSS
MP1 pp A VDD VDD PMOS W=37u L=1u
MP2 p B pp VDD PMOS W=37u L=1u
MN1 n A VSS VSS NMOS W=6.5u L=1u
MN2 n B VSS VSS NMOS W=6.5u L=1u
XRP p Y VDD F_RR W=2.8u L=30u
XRN Y n VDD F_RR W=2.8u L=30u
.ends NOR
