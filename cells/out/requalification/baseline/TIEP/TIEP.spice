* RR30 schematic connectivity; lengths in micrometres
.subckt TIEP Y VDD VMID VSS
XRT Y VDD VDD F_RR W=2.8u L=30u
.ends TIEP
