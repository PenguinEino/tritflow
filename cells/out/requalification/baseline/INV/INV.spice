* RR30 schematic connectivity; lengths in micrometres
.subckt INV A Y VDD VMID VSS
XMP p A VDD VDD PMOS W=13.5u L=1u
XMN n A VSS VSS NMOS W=5u L=1u
XRP p Y VDD F_RR W=2.8u L=30u
XRN Y n VDD F_RR W=2.8u L=30u
.ends INV
