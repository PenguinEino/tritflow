* RR30 schematic connectivity; lengths in micrometres
.subckt NANY A B Y VDD VMID VSS
MP1 pp A VDD VDD PMOS W=34u L=1u
MP2 p B pp VDD PMOS W=34u L=1u
MN1 n A nn VSS NMOS W=11u L=1u
MN2 nn B VSS VSS NMOS W=11u L=1u
MCP1 c1 A Y VDD PMOS W=14u L=1u
MCN1 c1 B VMID VSS NMOS W=8u L=1u
MCP2 c2 B Y VDD PMOS W=14u L=1u
MCN2 c2 A VMID VSS NMOS W=8u L=1u
XRP p Y VDD F_RR W=2.8u L=30u
XRN Y n VDD F_RR W=2.8u L=30u
.ends NANY
