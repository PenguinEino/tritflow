* RR30 schematic connectivity; lengths in micrometres
.subckt FILL VDD VMID VSS
.ends FILL
