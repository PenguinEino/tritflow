* TritFlow extracted DC sanity
.include "/home/ishi-kai/pdk/TR-1um-pinned/libs.tech/spice/models/ip62_models"
.include "/home/ishi-kai/code-a-chip/cells/.cells-pinned-kdw8spcg/TIEP/TIEP.ext.spice"
VDD VDD 0 5
VMID VMID 0 0
VSS VSS 0 -5
XU Y VDD VMID VSS TIEP
.temp 27
.options rshunt=1e12
.nodeset v(Y)=5
.control
op
print v(Y)
quit
.endc
.end
