* RR30 schematic connectivity; lengths in micrometres
.subckt TIEZ Y VDD VMID VSS
XRT Y VMID VDD F_RR W=2.8u L=30u
.ends TIEZ
