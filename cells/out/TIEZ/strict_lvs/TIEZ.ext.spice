* Created by KLayout
*** My special header ***

* cell TIEZ
* pin VDD
* pin VMID
* pin Y
.SUBCKT TIEZ VDD VMID Y VSS
* device instance $1 r0 *1 36,55 F_RR
XR$1 VMID Y VDD F_RR R=10.7142857143 L=30u W=2.8u A=84p P=65.6u m=1
.ENDS TIEZ
