* RR30 schematic connectivity; lengths in micrometres
.subckt NAND A B Y VDD VMID VSS
MP1 p A VDD VDD PMOS W=19u L=1u
MP2 p B VDD VDD PMOS W=19u L=1u
MN1 n A nn VSS NMOS W=13u L=1u
MN2 nn B VSS VSS NMOS W=13u L=1u
XRP p Y VDD F_RR W=2.8u L=30u
XRN Y n VDD F_RR W=2.8u L=30u
.ends NAND
