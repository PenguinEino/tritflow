* RR30 schematic connectivity; lengths in micrometres
.subckt INV A Y VDD VMID VSS
XMP p A VDD VDD PMOS W=13.5u L=1u
XMN n A VSS VSS NMOS W=5u L=1u
XRP p Y VDD F_RR W=2.8u L=30u
XRN Y n VDD F_RR W=2.8u L=30u
.ends INV
* RR30 schematic connectivity; lengths in micrometres
.subckt NAND A B Y VDD VMID VSS
XP1 p A VDD VDD PMOS W=19u L=1u
XP2 p B VDD VDD PMOS W=19u L=1u
XN1 n A nn VSS NMOS W=13u L=1u
XN2 nn B VSS VSS NMOS W=13u L=1u
XRP p Y VDD F_RR W=2.8u L=30u
XRN Y n VDD F_RR W=2.8u L=30u
.ends NAND
* RR30 schematic connectivity; lengths in micrometres
.subckt NOR A B Y VDD VMID VSS
XP1 pp A VDD VDD PMOS W=37u L=1u
XP2 p B pp VDD PMOS W=37u L=1u
XN1 n A VSS VSS NMOS W=6.5u L=1u
XN2 n B VSS VSS NMOS W=6.5u L=1u
XRP p Y VDD F_RR W=2.8u L=30u
XRN Y n VDD F_RR W=2.8u L=30u
.ends NOR
* RR30 schematic connectivity; lengths in micrometres
.subckt NANY A B Y VDD VMID VSS
XP1 pp A VDD VDD PMOS W=34u L=1u
XP2 p B pp VDD PMOS W=34u L=1u
XN1 n A nn VSS NMOS W=11u L=1u
XN2 nn B VSS VSS NMOS W=11u L=1u
XCP1 c1 A Y VDD PMOS W=14u L=1u
XCN1 c1 B VMID VSS NMOS W=8u L=1u
XCP2 c2 B Y VDD PMOS W=14u L=1u
XCN2 c2 A VMID VSS NMOS W=8u L=1u
XRP p Y VDD F_RR W=2.8u L=30u
XRN Y n VDD F_RR W=2.8u L=30u
.ends NANY
* RR30 schematic connectivity; lengths in micrometres
.subckt BUF A Y VDD VMID VSS
XMP0 p0 A VDD VDD PMOS W=13.5u L=1u
XMN0 n0 A VSS VSS NMOS W=5u L=1u
XMP1 p1 mid VDD VDD PMOS W=13.5u L=1u
XMN1 n1 mid VSS VSS NMOS W=5u L=1u
XRP0 p0 mid VDD F_RR W=2.8u L=30u
XRN0 mid n0 VDD F_RR W=2.8u L=30u
XRP1 p1 Y VDD F_RR W=2.8u L=30u
XRN1 Y n1 VDD F_RR W=2.8u L=30u
.ends BUF
* RR30 schematic connectivity; lengths in micrometres
.subckt TIEP Y VDD VMID VSS
XRT Y VDD VDD F_RR W=2.8u L=30u
.ends TIEP
* RR30 schematic connectivity; lengths in micrometres
.subckt TIEZ Y VDD VMID VSS
XRT Y VMID VDD F_RR W=2.8u L=30u
.ends TIEZ
* RR30 schematic connectivity; lengths in micrometres
.subckt TIEN Y VDD VMID VSS
XRT Y VSS VDD F_RR W=2.8u L=30u
.ends TIEN
* RR30 schematic connectivity; lengths in micrometres
.subckt FILL VDD VMID VSS
.ends FILL
