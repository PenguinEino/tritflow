* Created by KLayout
*** My special header ***

* cell TIEN
* pin VDD
* pin VSS
* pin Y
.SUBCKT TIEN VDD VSS Y
* device instance $1 r0 *1 51,200 F_RR
XR$1 Y VSS VDD F_RR R=10.7142857143 L=30u W=2.8u A=84p P=65.6u m=1
.ENDS TIEN
