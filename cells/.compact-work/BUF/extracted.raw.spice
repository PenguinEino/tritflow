* Created by KLayout
*** My special header ***

* cell BUF
* pin A
* pin VDD
* pin VSS
* pin Y
.SUBCKT BUF A VDD VSS Y
* device instance $1 r0 *1 27,200 PMOS
XM$1 VDD A \$30 VDD PMOS L=1u W=13.5u AS=37.8p AD=37.8p PS=32.6u PD=32.6u
* device instance $2 r0 *1 123,200 PMOS
XM$2 VDD \$15 \$31 VDD PMOS L=1u W=13.5u AS=37.8p AD=37.8p PS=32.6u PD=32.6u
* device instance $3 r0 *1 75,200 NMOS
XM$3 VSS A \$28 VSS NMOS L=1u W=5u AS=14p AD=14p PS=15.6u PD=15.6u
* device instance $4 r0 *1 171,200 NMOS
XM$4 VSS \$15 \$29 VSS NMOS L=1u W=5u AS=14p AD=14p PS=15.6u PD=15.6u
* device instance $5 r0 *1 243,200 F_RR
XR$5 \$30 \$15 VDD F_RR R=10.7142857143 L=30u W=2.8u A=84p P=65.6u m=1
* device instance $6 r0 *1 459,200 F_RR
XR$6 Y \$29 VDD F_RR R=10.7142857143 L=30u W=2.8u A=84p P=65.6u m=1
* device instance $7 r0 *1 387,200 F_RR
XR$7 \$31 Y VDD F_RR R=10.7142857143 L=30u W=2.8u A=84p P=65.6u m=1
* device instance $8 r0 *1 315,200 F_RR
XR$8 \$15 \$28 VDD F_RR R=10.7142857143 L=30u W=2.8u A=84p P=65.6u m=1
.ENDS BUF
