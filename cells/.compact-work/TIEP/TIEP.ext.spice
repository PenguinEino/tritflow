* PDK extraction; public ports normalized, no parasitic RC
.subckt TIEP Y VDD VMID VSS
* device instance $1 r0 *1 51,200 F_RR
XR$1 Y VDD VDD F_RR R=10.7142857143 L=30u W=2.8u A=84p P=65.6u m=1

.ends TIEP
