* PDK extraction; public ports normalized, no parasitic RC
.subckt NANY A B Y VDD VMID VSS
* device instance $1 r0 *1 219,200 PMOS
XM$1 Y A \$38 VDD PMOS L=1u W=14u AS=39.2p AD=39.2p PS=33.6u PD=33.6u
* device instance $2 r0 *1 315,200 PMOS
XM$2 Y B \$42 VDD PMOS L=1u W=14u AS=39.2p AD=39.2p PS=33.6u PD=33.6u
* device instance $3 r0 *1 27,200 PMOS
XM$3 VDD A \$27 VDD PMOS L=1u W=34u AS=95.2p AD=95.2p PS=73.6u PD=73.6u
* device instance $4 r0 *1 75,200 PMOS
XM$4 \$27 B \$23 VDD PMOS L=1u W=34u AS=95.2p AD=95.2p PS=73.6u PD=73.6u
* device instance $5 r0 *1 267,200 NMOS
XM$5 VMID B \$38 VSS NMOS L=1u W=8u AS=22.4p AD=22.4p PS=21.6u PD=21.6u
* device instance $6 r0 *1 363,200 NMOS
XM$6 VMID A \$42 VSS NMOS L=1u W=8u AS=22.4p AD=22.4p PS=21.6u PD=21.6u
* device instance $7 r0 *1 123,200 NMOS
XM$7 \$28 A \$32 VSS NMOS L=1u W=11u AS=30.8p AD=30.8p PS=27.6u PD=27.6u
* device instance $8 r0 *1 171,200 NMOS
XM$8 VSS B \$28 VSS NMOS L=1u W=11u AS=30.8p AD=30.8p PS=27.6u PD=27.6u
* device instance $9 r0 *1 435,200 F_RR
XR$9 \$23 Y VDD F_RR R=10.7142857143 L=30u W=2.8u A=84p P=65.6u m=1
* device instance $10 r0 *1 507,200 F_RR
XR$10 Y \$32 VDD F_RR R=10.7142857143 L=30u W=2.8u A=84p P=65.6u m=1

.ends NANY
