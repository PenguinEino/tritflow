* RR30 schematic connectivity; lengths in micrometres
.subckt NANY A B Y VDD VMID VSS
XP1 pp A VDD VDD PMOS W=34u L=1u
XP2 p B pp VDD PMOS W=34u L=1u
XN1 n A nn VSS NMOS W=11u L=1u
XN2 nn B VSS VSS NMOS W=11u L=1u
XCP1 c1 A Y VDD PMOS W=14u L=1u
XCN1 c1 B VMID VSS NMOS W=8u L=1u
XCP2 c2 B Y VDD PMOS W=14u L=1u
XCN2 c2 A VMID VSS NMOS W=8u L=1u
XRP p Y VDD F_RR W=2.8u L=30u
XRN Y n VDD F_RR W=2.8u L=30u
.ends NANY
