* PDK extraction; public ports normalized, no parasitic RC
.subckt INV A Y VDD VMID VSS
* device instance $1 r0 *1 27,200 PMOS
XM$1 VDD A \$21 VDD PMOS L=1u W=13.5u AS=37.8p AD=37.8p PS=32.6u PD=32.6u
* device instance $2 r0 *1 75,200 NMOS
XM$2 VSS A \$20 VSS NMOS L=1u W=5u AS=14p AD=14p PS=15.6u PD=15.6u
* device instance $3 r0 *1 147,200 F_RR
XR$3 \$21 Y VDD F_RR R=10.7142857143 L=30u W=2.8u A=84p P=65.6u m=1
* device instance $4 r0 *1 219,200 F_RR
XR$4 Y \$20 VDD F_RR R=10.7142857143 L=30u W=2.8u A=84p P=65.6u m=1

.ends INV
