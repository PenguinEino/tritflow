* PDK extraction; public ports normalized, no parasitic RC
.subckt NOR A B Y VDD VMID VSS
* device instance $1 r0 *1 27,200 PMOS
XM$1 VDD A \$26 VDD PMOS L=1u W=37u AS=103.6p AD=103.6p PS=79.6u PD=79.6u
* device instance $2 r0 *1 75,200 PMOS
XM$2 \$26 B \$25 VDD PMOS L=1u W=37u AS=103.6p AD=103.6p PS=79.6u PD=79.6u
* device instance $3 r0 *1 123,200 NMOS
XM$3 VSS A \$24 VSS NMOS L=1u W=6.5u AS=18.2p AD=18.2p PS=18.6u PD=18.6u
* device instance $4 r0 *1 171,200 NMOS
XM$4 VSS B \$24 VSS NMOS L=1u W=6.5u AS=18.2p AD=18.2p PS=18.6u PD=18.6u
* device instance $5 r0 *1 243,200 F_RR
XR$5 \$25 Y VDD F_RR R=10.7142857143 L=30u W=2.8u A=84p P=65.6u m=1
* device instance $6 r0 *1 315,200 F_RR
XR$6 Y \$24 VDD F_RR R=10.7142857143 L=30u W=2.8u A=84p P=65.6u m=1

.ends NOR
