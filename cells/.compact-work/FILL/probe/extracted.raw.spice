* Created by KLayout
*** My special header ***

* cell FILL_PROBE
* pin VDD
* pin VMID
* pin VSS
* pin YN
* pin YP
* pin YZ
.SUBCKT FILL_PROBE VDD VMID VSS YN YP YZ
* cell instance $1 r0 *1 24,0
X$1 VDD YP TIEP
* cell instance $2 r0 *1 198,0
X$2 VDD VMID YZ TIEZ
* cell instance $4 r0 *1 372,0
X$4 VDD YN VSS TIEN
.ENDS FILL_PROBE

* cell TIEN
* pin VDD
* pin Y
* pin VSS
.SUBCKT TIEN VDD Y VSS
* device instance $1 r0 *1 51,200 F_RR
XR$1 Y VSS VDD F_RR R=10.7142857143 L=30u W=2.8u A=84p P=65.6u m=1
.ENDS TIEN

* cell TIEZ
* pin VDD
* pin VMID
* pin Y
.SUBCKT TIEZ VDD VMID Y
* device instance $1 r0 *1 51,200 F_RR
XR$1 Y VMID VDD F_RR R=10.7142857143 L=30u W=2.8u A=84p P=65.6u m=1
.ENDS TIEZ

* cell TIEP
* pin VDD
* pin Y
.SUBCKT TIEP VDD Y
* device instance $1 r0 *1 51,200 F_RR
XR$1 Y VDD VDD F_RR R=10.7142857143 L=30u W=2.8u A=84p P=65.6u m=1
.ENDS TIEP
