* Created by KLayout
*** My special header ***

* cell NAND
* pin A
* pin B
* pin VDD
* pin VSS
* pin Y
.SUBCKT NAND A B VDD VSS Y
* device instance $1 r0 *1 27,200 PMOS
XM$1 VDD A \$26 VDD PMOS L=1u W=19u AS=53.2p AD=53.2p PS=43.6u PD=43.6u
* device instance $2 r0 *1 75,200 PMOS
XM$2 VDD B \$26 VDD PMOS L=1u W=19u AS=53.2p AD=53.2p PS=43.6u PD=43.6u
* device instance $3 r0 *1 123,200 NMOS
XM$3 \$25 A \$24 VSS NMOS L=1u W=13u AS=36.4p AD=36.4p PS=31.6u PD=31.6u
* device instance $4 r0 *1 171,200 NMOS
XM$4 VSS B \$25 VSS NMOS L=1u W=13u AS=36.4p AD=36.4p PS=31.6u PD=31.6u
* device instance $5 r0 *1 243,200 F_RR
XR$5 \$26 Y VDD F_RR R=10.7142857143 L=30u W=2.8u A=84p P=65.6u m=1
* device instance $6 r0 *1 315,200 F_RR
XR$6 Y \$24 VDD F_RR R=10.7142857143 L=30u W=2.8u A=84p P=65.6u m=1
.ENDS NAND
