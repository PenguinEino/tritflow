* Fresh current Xschem reference, renamed public ports only
.subckt NAND A B Y VDD VMID VSS
MXM1 net1 A VDD VDD PMOS w=19u l=1u
MXM3 net1 B VDD VDD PMOS w=19u l=1u
XR1 net1 Y VDD F_RR w=2.8e-06 l=30e-06
XR2 Y net2 VDD F_RR w=2.8e-06 l=30e-06
MXM2 net2 A net3 VSS NMOS w=13u l=1u
MXM4 net3 B VSS VSS NMOS w=13u l=1u
.ends NAND
