* Created by KLayout
*** My special header ***

* cell TDFF
* pin CLK
* pin D
* pin Q
* pin VDD
* pin VSS
.subckt TDFF D CLK Q VDD VMID VSS
* device instance $1 r0 *1 30,100 PMOS
XM$1 node_15 CLK VDD VDD PMOS L=1u W=3.4u AS=9.52p AD=9.52p PS=12.4u PD=12.4u
* device instance $2 r0 *1 90,90 PMOS
XM$2 node_17 CLK VDD VDD PMOS L=1u W=60u AS=168p AD=168p PS=125.6u PD=125.6u
* device instance $3 r0 *1 211.2,56 PMOS
XM$3 node_68 node_13 VDD VDD PMOS L=1u W=13.5u AS=37.8p AD=37.8p PS=32.6u PD=32.6u
* device instance $4 r0 *1 450,100 PMOS
XM$4 node_13 node_15 node_23 VDD PMOS L=1u W=13.5u AS=37.8p AD=37.8p PS=32.6u PD=32.6u
* device instance $5 r0 *1 168,100 PMOS
XM$5 node_13 node_16 node_19 VDD PMOS L=1u W=13.5u AS=37.8p AD=37.8p PS=32.6u PD=32.6u
* device instance $6 r0 *1 1051.2,56 PMOS
XM$6 node_80 D VDD VDD PMOS L=1u W=13.5u AS=37.8p AD=37.8p PS=32.6u PD=32.6u
* device instance $7 r0 *1 60,100 PMOS
XM$7 node_16 node_15 VDD VDD PMOS L=1u W=13.5u AS=37.8p AD=37.8p PS=32.6u PD=32.6u
* device instance $8 r0 *1 618,100 PMOS
XM$8 node_27 node_17 node_26 VDD PMOS L=1u W=13.5u AS=37.8p AD=37.8p PS=32.6u PD=32.6u
* device instance $9 r0 *1 120,100 PMOS
XM$9 node_18 node_17 VDD VDD PMOS L=1u W=13.5u AS=37.8p AD=37.8p PS=32.6u PD=32.6u
* device instance $10 r0 *1 894,100 PMOS
XM$10 node_27 node_18 node_30 VDD PMOS L=1u W=13.5u AS=37.8p AD=37.8p PS=32.6u PD=32.6u
* device instance $11 r0 *1 319.2,56 PMOS
XM$11 node_69 node_22 VDD VDD PMOS L=1u W=13.5u AS=37.8p AD=37.8p PS=32.6u PD=32.6u
* device instance $12 r0 *1 487.2,56 PMOS
XM$12 node_73 node_22 VDD VDD PMOS L=1u W=13.5u AS=37.8p AD=37.8p PS=32.6u PD=32.6u
* device instance $13 r0 *1 655.2,56 PMOS
XM$13 node_76 node_27 VDD VDD PMOS L=1u W=13.5u AS=37.8p AD=37.8p PS=32.6u PD=32.6u
* device instance $14 r0 *1 931.2,56 PMOS
XM$14 node_79 node_29 VDD VDD PMOS L=1u W=13.5u AS=37.8p AD=37.8p PS=32.6u PD=32.6u
* device instance $15 r0 *1 763.2,56 PMOS
XM$15 node_77 node_29 VDD VDD PMOS L=1u W=13.5u AS=37.8p AD=37.8p PS=32.6u PD=32.6u
* device instance $16 r0 *1 1159.2,56 PMOS
XM$16 node_81 node_33 VDD VDD PMOS L=1u W=13.5u AS=37.8p AD=37.8p PS=32.6u PD=32.6u
* device instance $17 r0 *1 30,32 NMOS
XM$17 node_15 CLK VSS VSS NMOS L=1u W=30u AS=84p AD=84p PS=65.6u PD=65.6u
* device instance $18 r0 *1 90,30 NMOS
XM$18 node_17 CLK VSS VSS NMOS L=1u W=3.4u AS=9.52p AD=9.52p PS=12.4u PD=12.4u
* device instance $19 r0 *1 211.2,26 NMOS
XM$19 node_4 node_13 VSS VSS NMOS L=1u W=5u AS=14p AD=14p PS=15.6u PD=15.6u
* device instance $20 r0 *1 319.2,26 NMOS
XM$20 node_5 node_22 VSS VSS NMOS L=1u W=5u AS=14p AD=14p PS=15.6u PD=15.6u
* device instance $21 r0 *1 487.2,26 NMOS
XM$21 node_6 node_22 VSS VSS NMOS L=1u W=5u AS=14p AD=14p PS=15.6u PD=15.6u
* device instance $22 r0 *1 655.2,26 NMOS
XM$22 node_7 node_27 VSS VSS NMOS L=1u W=5u AS=14p AD=14p PS=15.6u PD=15.6u
* device instance $23 r0 *1 763.2,26 NMOS
XM$23 node_8 node_29 VSS VSS NMOS L=1u W=5u AS=14p AD=14p PS=15.6u PD=15.6u
* device instance $24 r0 *1 931.2,26 NMOS
XM$24 node_9 node_29 VSS VSS NMOS L=1u W=5u AS=14p AD=14p PS=15.6u PD=15.6u
* device instance $25 r0 *1 1051.2,26 NMOS
XM$25 node_10 D VSS VSS NMOS L=1u W=5u AS=14p AD=14p PS=15.6u PD=15.6u
* device instance $26 r0 *1 1159.2,26 NMOS
XM$26 node_11 node_33 VSS VSS NMOS L=1u W=5u AS=14p AD=14p PS=15.6u PD=15.6u
* device instance $27 r0 *1 426,30 NMOS
XM$27 node_13 node_16 node_23 VSS NMOS L=1u W=5u AS=14p AD=14p PS=15.6u PD=15.6u
* device instance $28 r0 *1 144,30 NMOS
XM$28 node_13 node_15 node_19 VSS NMOS L=1u W=5u AS=14p AD=14p PS=15.6u PD=15.6u
* device instance $29 r0 *1 60,30 NMOS
XM$29 node_16 node_15 VSS VSS NMOS L=1u W=5u AS=14p AD=14p PS=15.6u PD=15.6u
* device instance $30 r0 *1 120,30 NMOS
XM$30 node_18 node_17 VSS VSS NMOS L=1u W=5u AS=14p AD=14p PS=15.6u PD=15.6u
* device instance $31 r0 *1 870,30 NMOS
XM$31 node_27 node_17 node_30 VSS NMOS L=1u W=5u AS=14p AD=14p PS=15.6u PD=15.6u
* device instance $32 r0 *1 594,30 NMOS
XM$32 node_27 node_18 node_26 VSS NMOS L=1u W=5u AS=14p AD=14p PS=15.6u PD=15.6u
* device instance $33 r0 *1 262,44 F_RR
XR$33 node_4 node_22 VDD F_RR R=10.7142857143 L=30u W=2.8u A=84p P=65.6u m=1
* device instance $34 r0 *1 370,44 F_RR
XR$34 node_5 node_23 VDD F_RR R=10.7142857143 L=30u W=2.8u A=84p P=65.6u m=1
* device instance $35 r0 *1 538,44 F_RR
XR$35 node_6 node_26 VDD F_RR R=10.7142857143 L=30u W=2.8u A=84p P=65.6u m=1
* device instance $36 r0 *1 706,44 F_RR
XR$36 node_7 node_29 VDD F_RR R=10.7142857143 L=30u W=2.8u A=84p P=65.6u m=1
* device instance $37 r0 *1 814,44 F_RR
XR$37 node_8 node_30 VDD F_RR R=10.7142857143 L=30u W=2.8u A=84p P=65.6u m=1
* device instance $38 r0 *1 982,44 F_RR
XR$38 node_9 Q VDD F_RR R=10.7142857143 L=30u W=2.8u A=84p P=65.6u m=1
* device instance $39 r0 *1 1102,44 F_RR
XR$39 node_10 node_33 VDD F_RR R=10.7142857143 L=30u W=2.8u A=84p P=65.6u m=1
* device instance $40 r0 *1 1210,44 F_RR
XR$40 node_11 node_19 VDD F_RR R=10.7142857143 L=30u W=2.8u A=84p P=65.6u m=1
* device instance $41 r0 *1 1210,57 F_RR
XR$41 node_81 node_19 VDD F_RR R=10.7142857143 L=30u W=2.8u A=84p P=65.6u m=1
* device instance $42 r0 *1 262,57 F_RR
XR$42 node_68 node_22 VDD F_RR R=10.7142857143 L=30u W=2.8u A=84p P=65.6u m=1
* device instance $43 r0 *1 370,57 F_RR
XR$43 node_69 node_23 VDD F_RR R=10.7142857143 L=30u W=2.8u A=84p P=65.6u m=1
* device instance $44 r0 *1 538,57 F_RR
XR$44 node_73 node_26 VDD F_RR R=10.7142857143 L=30u W=2.8u A=84p P=65.6u m=1
* device instance $45 r0 *1 706,57 F_RR
XR$45 node_76 node_29 VDD F_RR R=10.7142857143 L=30u W=2.8u A=84p P=65.6u m=1
* device instance $46 r0 *1 814,57 F_RR
XR$46 node_77 node_30 VDD F_RR R=10.7142857143 L=30u W=2.8u A=84p P=65.6u m=1
* device instance $47 r0 *1 1102,57 F_RR
XR$47 node_80 node_33 VDD F_RR R=10.7142857143 L=30u W=2.8u A=84p P=65.6u m=1
* device instance $48 r0 *1 982,57 F_RR
XR$48 node_79 Q VDD F_RR R=10.7142857143 L=30u W=2.8u A=84p P=65.6u m=1
.ENDS TDFF
