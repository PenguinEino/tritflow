* TritFlow cell netlist: trits -1/0/+1 at -5/0/+5 V.
.subckt full_add a b cin sum cout VDD VMID VSS
Xtf_6861312e675f74 a b _n0 VDD VMID VSS NANY
Xtf_6861312e675f6e61 a _n1 VDD VMID VSS INV
Xtf_6861312e675f75 b _n0 _n2 VDD VMID VSS NANY
Xtf_6861312e675f63 _n1 _n2 _n3 VDD VMID VSS NANY
Xtf_6861312e675f64 _n0 _n3 _n4 VDD VMID VSS NANY
Xtf_6861312e675f6e64 _n4 _n5 VDD VMID VSS INV
Xtf_6861312e675f73 _n5 _n3 _n6 VDD VMID VSS NANY
Xtf_6861322e675f74 _n6 cin _n7 VDD VMID VSS NANY
Xtf_6861322e675f6e61 _n6 _n8 VDD VMID VSS INV
Xtf_6861322e675f75 cin _n7 _n9 VDD VMID VSS NANY
Xtf_6861322e675f63 _n8 _n9 _n10 VDD VMID VSS NANY
Xtf_6861322e675f64 _n7 _n10 _n11 VDD VMID VSS NANY
Xg_nc _n3 _n10 _n14 VDD VMID VSS NANY
Xtf_6861322e675f6e64 _n11 _n12 VDD VMID VSS INV
Xg_cout _n14 cout VDD VMID VSS INV
Xtf_6861322e675f73 _n12 _n10 sum VDD VMID VSS NANY
.ends full_add

* RR30 schematic connectivity; lengths in micrometres
.subckt INV A Y VDD VMID VSS
XMP p A VDD VDD PMOS W=13.5u L=1u
XMN n A VSS VSS NMOS W=5u L=1u
XRP p Y VDD F_RR W=2.8u L=30u
XRN Y n VDD F_RR W=2.8u L=30u
.ends INV
* RR30 schematic connectivity; lengths in micrometres
.subckt NAND A B Y VDD VMID VSS
XP1 p A VDD VDD PMOS W=19u L=1u
XP2 p B VDD VDD PMOS W=19u L=1u
XN1 n A nn VSS NMOS W=13u L=1u
XN2 nn B VSS VSS NMOS W=13u L=1u
XRP p Y VDD F_RR W=2.8u L=30u
XRN Y n VDD F_RR W=2.8u L=30u
.ends NAND
* RR30 schematic connectivity; lengths in micrometres
.subckt NOR A B Y VDD VMID VSS
XP1 pp A VDD VDD PMOS W=37u L=1u
XP2 p B pp VDD PMOS W=37u L=1u
XN1 n A VSS VSS NMOS W=6.5u L=1u
XN2 n B VSS VSS NMOS W=6.5u L=1u
XRP p Y VDD F_RR W=2.8u L=30u
XRN Y n VDD F_RR W=2.8u L=30u
.ends NOR
* RR30 schematic connectivity; lengths in micrometres
.subckt NANY A B Y VDD VMID VSS
XP1 pp A VDD VDD PMOS W=34u L=1u
XP2 p B pp VDD PMOS W=34u L=1u
XN1 n A nn VSS NMOS W=11u L=1u
XN2 nn B VSS VSS NMOS W=11u L=1u
XCP1 c1 A Y VDD PMOS W=14u L=1u
XCN1 c1 B VMID VSS NMOS W=8u L=1u
XCP2 c2 B Y VDD PMOS W=14u L=1u
XCN2 c2 A VMID VSS NMOS W=8u L=1u
XRP p Y VDD F_RR W=2.8u L=30u
XRN Y n VDD F_RR W=2.8u L=30u
.ends NANY
* RR30 schematic connectivity; lengths in micrometres
.subckt BUF A Y VDD VMID VSS
XMP0 p0 A VDD VDD PMOS W=13.5u L=1u
XMN0 n0 A VSS VSS NMOS W=5u L=1u
XMP1 p1 mid VDD VDD PMOS W=13.5u L=1u
XMN1 n1 mid VSS VSS NMOS W=5u L=1u
XRP0 p0 mid VDD F_RR W=2.8u L=30u
XRN0 mid n0 VDD F_RR W=2.8u L=30u
XRP1 p1 Y VDD F_RR W=2.8u L=30u
XRN1 Y n1 VDD F_RR W=2.8u L=30u
.ends BUF
* RR30 schematic connectivity; lengths in micrometres
.subckt TIEP Y VDD VMID VSS
XRT Y VDD VDD F_RR W=2.8u L=30u
.ends TIEP
* RR30 schematic connectivity; lengths in micrometres
.subckt TIEZ Y VDD VMID VSS
XRT Y VMID VDD F_RR W=2.8u L=30u
.ends TIEZ
* RR30 schematic connectivity; lengths in micrometres
.subckt TIEN Y VDD VMID VSS
XRT Y VSS VDD F_RR W=2.8u L=30u
.ends TIEN
* RR30 schematic connectivity; lengths in micrometres
.subckt FILL VDD VMID VSS
.ends FILL

.subckt tr_1um_full_add a b cin sum cout VDD VMID VSS ESD_VDD NC03 NC07 NC09 NC10 NC14
Xmacro a b cin sum cout VDD VMID VSS full_add
Xframe VDD ESD_VDD VDD VDD NC14 NC03 cin VMID b cout a sum NC10 NC07 NC09 VSS OSS_FRAME
.ends tr_1um_full_add

* Independent stock-frame reference: pinned TR-1um_frame Xschem schematics.
.subckt OSS_FRAME P1 VDD P2 P15 P14 P3 P4 P13 P5 P12 P6 P11 P10 P7 P9 VSS
Xana1 VDD P1 VSS OSS_ESD_5V_ANA
Xana2 VDD P2 VSS OSS_ESD_5V_ANA
Xana3 VDD P15 VSS OSS_ESD_5V_ANA
Xana4 VDD P14 VSS OSS_ESD_5V_ANA
Xana5 VDD P3 VSS OSS_ESD_5V_ANA
Xana6 VDD P4 VSS OSS_ESD_5V_ANA
Xana7 VDD P13 VSS OSS_ESD_5V_ANA
Xana8 VDD P5 VSS OSS_ESD_5V_ANA
Xana9 VDD P12 VSS OSS_ESD_5V_ANA
Xana10 VDD P6 VSS OSS_ESD_5V_ANA
Xana11 VDD P11 VSS OSS_ESD_5V_ANA
Xana12 VDD P10 VSS OSS_ESD_5V_ANA
Xana13 VDD P7 VSS OSS_ESD_5V_ANA
Xana14 VDD P9 VSS OSS_ESD_5V_ANA
Xvdd VDD VSS OSS_ESD_5V_VDD
Xvss VDD VSS OSS_ESD_5V_VSS
.ends OSS_FRAME
.subckt OSS_ESD_5V_ANA VDD PAD VSS
M1 PAD VDD VDD VDD PMOS w=500u l=2u
M2 PAD VSS VSS VSS NMOSE w=500u l=2u
.ends OSS_ESD_5V_ANA
.subckt OSS_ESD_5V_VDD VDD VSS
M1 VSS VDD VDD VDD PMOS w=500u l=2u
M2 VDD VSS VSS VSS NMOSE w=500u l=2u
.ends OSS_ESD_5V_VDD
.subckt OSS_ESD_5V_VSS VDD VSS
M1 VSS VDD VDD VDD PMOS w=500u l=2u
M2 VDD VSS VSS VSS NMOSE w=500u l=2u
.ends OSS_ESD_5V_VSS
