** sch_path: /home/ishi-kai/balanced-ternary-logic/nany.sch
.subckt nany a b vout VDD VSS VMID
*.PININFO VDD:B a:I b:I vout:O VSS:B VMID:B
MXM3 net2 b net1 VDD PMOS w=34u l=1u
XR2 net2 vout VDD F_RR w=2.8e-06 l=30e-06
XR1 vout net3 VDD F_RR w=2.8e-06 l=30e-06
MXM2 net3 a net4 VSS NMOS w=11u l=1u
MXM1 net4 b VSS VSS NMOS w=11u l=1u
MXM5 net1 a VDD VDD PMOS w=34u l=1u
MXM6 net5 a vout VDD PMOS w=14u l=1u
MXM7 net5 b VMID VSS NMOS w=8u l=1u
MXM8 net6 b vout VDD PMOS w=14u l=1u
MXM9 net6 a VMID VSS NMOS w=8u l=1u
.ends
